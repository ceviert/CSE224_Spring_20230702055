* NGSPICE file created from Main.ext - technology: sky130A

* Black-box entry subcircuit for sky130_fd_sc_hd__mux2_1 abstract view
.subckt sky130_fd_sc_hd__mux2_1 A0 A1 S VGND VNB VPB VPWR X
.ends

* Black-box entry subcircuit for sky130_fd_sc_hd__tapvpwrvgnd_1 abstract view
.subckt sky130_fd_sc_hd__tapvpwrvgnd_1 VGND VPWR
.ends

* Black-box entry subcircuit for sky130_fd_sc_hd__fill_1 abstract view
.subckt sky130_fd_sc_hd__fill_1 VGND VNB VPB VPWR
.ends

* Black-box entry subcircuit for sky130_fd_sc_hd__nand2_1 abstract view
.subckt sky130_fd_sc_hd__nand2_1 A B VGND VNB VPB VPWR Y
.ends

* Black-box entry subcircuit for sky130_fd_sc_hd__o21ai_4 abstract view
.subckt sky130_fd_sc_hd__o21ai_4 A1 A2 B1 VGND VNB VPB VPWR Y
.ends

* Black-box entry subcircuit for sky130_fd_sc_hd__and3b_1 abstract view
.subckt sky130_fd_sc_hd__and3b_1 A_N B C VGND VNB VPB VPWR X
.ends

* Black-box entry subcircuit for sky130_fd_sc_hd__nor2_1 abstract view
.subckt sky130_fd_sc_hd__nor2_1 A B VGND VNB VPB VPWR Y
.ends

* Black-box entry subcircuit for sky130_fd_sc_hd__o21ba_1 abstract view
.subckt sky130_fd_sc_hd__o21ba_1 A1 A2 B1_N VGND VNB VPB VPWR X
.ends

* Black-box entry subcircuit for sky130_fd_sc_hd__clkbuf_1 abstract view
.subckt sky130_fd_sc_hd__clkbuf_1 A VGND VNB VPB VPWR X
.ends

* Black-box entry subcircuit for sky130_fd_sc_hd__fill_2 abstract view
.subckt sky130_fd_sc_hd__fill_2 VGND VNB VPB VPWR
.ends

* Black-box entry subcircuit for sky130_ef_sc_hd__decap_12 abstract view
.subckt sky130_ef_sc_hd__decap_12 VPWR VGND VPB VNB
.ends

* Black-box entry subcircuit for sky130_fd_sc_hd__decap_6 abstract view
.subckt sky130_fd_sc_hd__decap_6 VGND VNB VPB VPWR
.ends

* Black-box entry subcircuit for sky130_fd_sc_hd__dlymetal6s2s_1 abstract view
.subckt sky130_fd_sc_hd__dlymetal6s2s_1 A VGND VNB VPB VPWR X
.ends

* Black-box entry subcircuit for sky130_fd_sc_hd__xnor2_1 abstract view
.subckt sky130_fd_sc_hd__xnor2_1 A B VGND VNB VPB VPWR Y
.ends

* Black-box entry subcircuit for sky130_fd_sc_hd__a21o_1 abstract view
.subckt sky130_fd_sc_hd__a21o_1 A1 A2 B1 VGND VNB VPB VPWR X
.ends

* Black-box entry subcircuit for sky130_fd_sc_hd__decap_8 abstract view
.subckt sky130_fd_sc_hd__decap_8 VGND VNB VPB VPWR
.ends

* Black-box entry subcircuit for sky130_fd_sc_hd__clkbuf_4 abstract view
.subckt sky130_fd_sc_hd__clkbuf_4 A VGND VNB VPB VPWR X
.ends

* Black-box entry subcircuit for sky130_fd_sc_hd__dfxtp_1 abstract view
.subckt sky130_fd_sc_hd__dfxtp_1 CLK D VGND VNB VPB VPWR Q
.ends

* Black-box entry subcircuit for sky130_fd_sc_hd__a2bb2o_1 abstract view
.subckt sky130_fd_sc_hd__a2bb2o_1 A1_N A2_N B1 B2 VGND VNB VPB VPWR X
.ends

* Black-box entry subcircuit for sky130_fd_sc_hd__buf_6 abstract view
.subckt sky130_fd_sc_hd__buf_6 A VGND VNB VPB VPWR X
.ends

* Black-box entry subcircuit for sky130_fd_sc_hd__xor2_1 abstract view
.subckt sky130_fd_sc_hd__xor2_1 A B VGND VNB VPB VPWR X
.ends

* Black-box entry subcircuit for sky130_fd_sc_hd__a31o_1 abstract view
.subckt sky130_fd_sc_hd__a31o_1 A1 A2 A3 B1 VGND VNB VPB VPWR X
.ends

* Black-box entry subcircuit for sky130_fd_sc_hd__a21oi_1 abstract view
.subckt sky130_fd_sc_hd__a21oi_1 A1 A2 B1 VGND VNB VPB VPWR Y
.ends

* Black-box entry subcircuit for sky130_fd_sc_hd__buf_1 abstract view
.subckt sky130_fd_sc_hd__buf_1 A VGND VNB VPB VPWR X
.ends

* Black-box entry subcircuit for sky130_fd_sc_hd__decap_4 abstract view
.subckt sky130_fd_sc_hd__decap_4 VGND VNB VPB VPWR
.ends

* Black-box entry subcircuit for sky130_fd_sc_hd__and2_1 abstract view
.subckt sky130_fd_sc_hd__and2_1 A B VGND VNB VPB VPWR X
.ends

* Black-box entry subcircuit for sky130_fd_sc_hd__a211o_1 abstract view
.subckt sky130_fd_sc_hd__a211o_1 A1 A2 B1 C1 VGND VNB VPB VPWR X
.ends

* Black-box entry subcircuit for sky130_fd_sc_hd__or2_1 abstract view
.subckt sky130_fd_sc_hd__or2_1 A B VGND VNB VPB VPWR X
.ends

* Black-box entry subcircuit for sky130_fd_sc_hd__a32o_1 abstract view
.subckt sky130_fd_sc_hd__a32o_1 A1 A2 A3 B1 B2 VGND VNB VPB VPWR X
.ends

* Black-box entry subcircuit for sky130_fd_sc_hd__decap_3 abstract view
.subckt sky130_fd_sc_hd__decap_3 VGND VNB VPB VPWR
.ends

* Black-box entry subcircuit for sky130_fd_sc_hd__diode_2 abstract view
.subckt sky130_fd_sc_hd__diode_2 DIODE VGND VNB VPB VPWR
.ends

* Black-box entry subcircuit for sky130_fd_sc_hd__dfrtp_1 abstract view
.subckt sky130_fd_sc_hd__dfrtp_1 CLK D RESET_B VGND VNB VPB VPWR Q
.ends

* Black-box entry subcircuit for sky130_fd_sc_hd__nand2_2 abstract view
.subckt sky130_fd_sc_hd__nand2_2 A B VGND VNB VPB VPWR Y
.ends

* Black-box entry subcircuit for sky130_fd_sc_hd__dlxtn_1 abstract view
.subckt sky130_fd_sc_hd__dlxtn_1 D GATE_N VGND VNB VPB VPWR Q
.ends

* Black-box entry subcircuit for sky130_fd_sc_hd__nor3_2 abstract view
.subckt sky130_fd_sc_hd__nor3_2 A B C VGND VNB VPB VPWR Y
.ends

* Black-box entry subcircuit for sky130_fd_sc_hd__inv_2 abstract view
.subckt sky130_fd_sc_hd__inv_2 A VGND VNB VPB VPWR Y
.ends

* Black-box entry subcircuit for sky130_fd_sc_hd__o31a_1 abstract view
.subckt sky130_fd_sc_hd__o31a_1 A1 A2 A3 B1 VGND VNB VPB VPWR X
.ends

* Black-box entry subcircuit for sky130_fd_sc_hd__o21ai_1 abstract view
.subckt sky130_fd_sc_hd__o21ai_1 A1 A2 B1 VGND VNB VPB VPWR Y
.ends

* Black-box entry subcircuit for sky130_fd_sc_hd__a21bo_1 abstract view
.subckt sky130_fd_sc_hd__a21bo_1 A1 A2 B1_N VGND VNB VPB VPWR X
.ends

* Black-box entry subcircuit for sky130_fd_sc_hd__o22ai_2 abstract view
.subckt sky130_fd_sc_hd__o22ai_2 A1 A2 B1 B2 VGND VNB VPB VPWR Y
.ends

* Black-box entry subcircuit for sky130_fd_sc_hd__or2b_1 abstract view
.subckt sky130_fd_sc_hd__or2b_1 A B_N VGND VNB VPB VPWR X
.ends

* Black-box entry subcircuit for sky130_fd_sc_hd__clkbuf_2 abstract view
.subckt sky130_fd_sc_hd__clkbuf_2 A VGND VNB VPB VPWR X
.ends

* Black-box entry subcircuit for sky130_fd_sc_hd__a2111oi_1 abstract view
.subckt sky130_fd_sc_hd__a2111oi_1 A1 A2 B1 C1 D1 VGND VNB VPB VPWR Y
.ends

* Black-box entry subcircuit for sky130_fd_sc_hd__o211a_1 abstract view
.subckt sky130_fd_sc_hd__o211a_1 A1 A2 B1 C1 VGND VNB VPB VPWR X
.ends

* Black-box entry subcircuit for sky130_fd_sc_hd__nor2_2 abstract view
.subckt sky130_fd_sc_hd__nor2_2 A B VGND VNB VPB VPWR Y
.ends

* Black-box entry subcircuit for sky130_fd_sc_hd__o22a_1 abstract view
.subckt sky130_fd_sc_hd__o22a_1 A1 A2 B1 B2 VGND VNB VPB VPWR X
.ends

* Black-box entry subcircuit for sky130_fd_sc_hd__o32a_1 abstract view
.subckt sky130_fd_sc_hd__o32a_1 A1 A2 A3 B1 B2 VGND VNB VPB VPWR X
.ends

* Black-box entry subcircuit for sky130_fd_sc_hd__o221a_1 abstract view
.subckt sky130_fd_sc_hd__o221a_1 A1 A2 B1 B2 C1 VGND VNB VPB VPWR X
.ends

* Black-box entry subcircuit for sky130_fd_sc_hd__nand2b_1 abstract view
.subckt sky130_fd_sc_hd__nand2b_1 A_N B VGND VNB VPB VPWR Y
.ends

* Black-box entry subcircuit for sky130_fd_sc_hd__or3_1 abstract view
.subckt sky130_fd_sc_hd__or3_1 A B C VGND VNB VPB VPWR X
.ends

* Black-box entry subcircuit for sky130_fd_sc_hd__and3_1 abstract view
.subckt sky130_fd_sc_hd__and3_1 A B C VGND VNB VPB VPWR X
.ends

* Black-box entry subcircuit for sky130_fd_sc_hd__and4_1 abstract view
.subckt sky130_fd_sc_hd__and4_1 A B C D VGND VNB VPB VPWR X
.ends

* Black-box entry subcircuit for sky130_fd_sc_hd__or3b_1 abstract view
.subckt sky130_fd_sc_hd__or3b_1 A B C_N VGND VNB VPB VPWR X
.ends

* Black-box entry subcircuit for sky130_fd_sc_hd__a31o_2 abstract view
.subckt sky130_fd_sc_hd__a31o_2 A1 A2 A3 B1 VGND VNB VPB VPWR X
.ends

* Black-box entry subcircuit for sky130_fd_sc_hd__buf_2 abstract view
.subckt sky130_fd_sc_hd__buf_2 A VGND VNB VPB VPWR X
.ends

* Black-box entry subcircuit for sky130_fd_sc_hd__dfrtp_4 abstract view
.subckt sky130_fd_sc_hd__dfrtp_4 CLK D RESET_B VGND VNB VPB VPWR Q
.ends

* Black-box entry subcircuit for sky130_fd_sc_hd__o22ai_1 abstract view
.subckt sky130_fd_sc_hd__o22ai_1 A1 A2 B1 B2 VGND VNB VPB VPWR Y
.ends

* Black-box entry subcircuit for sky130_fd_sc_hd__or4_1 abstract view
.subckt sky130_fd_sc_hd__or4_1 A B C D VGND VNB VPB VPWR X
.ends

* Black-box entry subcircuit for sky130_fd_sc_hd__o21a_1 abstract view
.subckt sky130_fd_sc_hd__o21a_1 A1 A2 B1 VGND VNB VPB VPWR X
.ends

* Black-box entry subcircuit for sky130_fd_sc_hd__mux2_2 abstract view
.subckt sky130_fd_sc_hd__mux2_2 A0 A1 S VGND VNB VPB VPWR X
.ends

* Black-box entry subcircuit for sky130_fd_sc_hd__a21oi_2 abstract view
.subckt sky130_fd_sc_hd__a21oi_2 A1 A2 B1 VGND VNB VPB VPWR Y
.ends

* Black-box entry subcircuit for sky130_fd_sc_hd__and3_2 abstract view
.subckt sky130_fd_sc_hd__and3_2 A B C VGND VNB VPB VPWR X
.ends

* Black-box entry subcircuit for sky130_fd_sc_hd__a311o_1 abstract view
.subckt sky130_fd_sc_hd__a311o_1 A1 A2 A3 B1 C1 VGND VNB VPB VPWR X
.ends

* Black-box entry subcircuit for sky130_fd_sc_hd__o21ai_2 abstract view
.subckt sky130_fd_sc_hd__o21ai_2 A1 A2 B1 VGND VNB VPB VPWR Y
.ends

* Black-box entry subcircuit for sky130_fd_sc_hd__o211ai_4 abstract view
.subckt sky130_fd_sc_hd__o211ai_4 A1 A2 B1 C1 VGND VNB VPB VPWR Y
.ends

* Black-box entry subcircuit for sky130_fd_sc_hd__a221o_1 abstract view
.subckt sky130_fd_sc_hd__a221o_1 A1 A2 B1 B2 C1 VGND VNB VPB VPWR X
.ends

* Black-box entry subcircuit for sky130_fd_sc_hd__and2b_1 abstract view
.subckt sky130_fd_sc_hd__and2b_1 A_N B VGND VNB VPB VPWR X
.ends

* Black-box entry subcircuit for sky130_fd_sc_hd__or2_2 abstract view
.subckt sky130_fd_sc_hd__or2_2 A B VGND VNB VPB VPWR X
.ends

* Black-box entry subcircuit for sky130_fd_sc_hd__nand3_1 abstract view
.subckt sky130_fd_sc_hd__nand3_1 A B C VGND VNB VPB VPWR Y
.ends

* Black-box entry subcircuit for sky130_fd_sc_hd__clkbuf_8 abstract view
.subckt sky130_fd_sc_hd__clkbuf_8 A VGND VNB VPB VPWR X
.ends

* Black-box entry subcircuit for sky130_fd_sc_hd__o21bai_1 abstract view
.subckt sky130_fd_sc_hd__o21bai_1 A1 A2 B1_N VGND VNB VPB VPWR Y
.ends

* Black-box entry subcircuit for sky130_fd_sc_hd__inv_8 abstract view
.subckt sky130_fd_sc_hd__inv_8 A VGND VNB VPB VPWR Y
.ends

* Black-box entry subcircuit for sky130_fd_sc_hd__nor2_4 abstract view
.subckt sky130_fd_sc_hd__nor2_4 A B VGND VNB VPB VPWR Y
.ends

* Black-box entry subcircuit for sky130_fd_sc_hd__o211ai_2 abstract view
.subckt sky130_fd_sc_hd__o211ai_2 A1 A2 B1 C1 VGND VNB VPB VPWR Y
.ends

* Black-box entry subcircuit for sky130_fd_sc_hd__o221a_2 abstract view
.subckt sky130_fd_sc_hd__o221a_2 A1 A2 B1 B2 C1 VGND VNB VPB VPWR X
.ends

* Black-box entry subcircuit for sky130_fd_sc_hd__bufinv_16 abstract view
.subckt sky130_fd_sc_hd__bufinv_16 A VGND VNB VPB VPWR Y
.ends

* Black-box entry subcircuit for sky130_fd_sc_hd__buf_4 abstract view
.subckt sky130_fd_sc_hd__buf_4 A VGND VNB VPB VPWR X
.ends

* Black-box entry subcircuit for sky130_fd_sc_hd__a22o_1 abstract view
.subckt sky130_fd_sc_hd__a22o_1 A1 A2 B1 B2 VGND VNB VPB VPWR X
.ends

* Black-box entry subcircuit for sky130_fd_sc_hd__or3b_2 abstract view
.subckt sky130_fd_sc_hd__or3b_2 A B C_N VGND VNB VPB VPWR X
.ends

* Black-box entry subcircuit for sky130_fd_sc_hd__and4bb_1 abstract view
.subckt sky130_fd_sc_hd__and4bb_1 A_N B_N C D VGND VNB VPB VPWR X
.ends

* Black-box entry subcircuit for sky130_fd_sc_hd__or4_4 abstract view
.subckt sky130_fd_sc_hd__or4_4 A B C D VGND VNB VPB VPWR X
.ends

* Black-box entry subcircuit for sky130_fd_sc_hd__and2_2 abstract view
.subckt sky130_fd_sc_hd__and2_2 A B VGND VNB VPB VPWR X
.ends

* Black-box entry subcircuit for sky130_fd_sc_hd__o2bb2a_1 abstract view
.subckt sky130_fd_sc_hd__o2bb2a_1 A1_N A2_N B1 B2 VGND VNB VPB VPWR X
.ends

* Black-box entry subcircuit for sky130_fd_sc_hd__xnor2_2 abstract view
.subckt sky130_fd_sc_hd__xnor2_2 A B VGND VNB VPB VPWR Y
.ends

* Black-box entry subcircuit for sky130_fd_sc_hd__o2111a_1 abstract view
.subckt sky130_fd_sc_hd__o2111a_1 A1 A2 B1 C1 D1 VGND VNB VPB VPWR X
.ends

* Black-box entry subcircuit for sky130_fd_sc_hd__clkinv_16 abstract view
.subckt sky130_fd_sc_hd__clkinv_16 A VGND VNB VPB VPWR Y
.ends

* Black-box entry subcircuit for sky130_fd_sc_hd__or4bb_1 abstract view
.subckt sky130_fd_sc_hd__or4bb_1 A B C_N D_N VGND VNB VPB VPWR X
.ends

* Black-box entry subcircuit for sky130_fd_sc_hd__o21a_2 abstract view
.subckt sky130_fd_sc_hd__o21a_2 A1 A2 B1 VGND VNB VPB VPWR X
.ends

* Black-box entry subcircuit for sky130_fd_sc_hd__dfxtp_4 abstract view
.subckt sky130_fd_sc_hd__dfxtp_4 CLK D VGND VNB VPB VPWR Q
.ends

* Black-box entry subcircuit for sky130_fd_sc_hd__clkbuf_16 abstract view
.subckt sky130_fd_sc_hd__clkbuf_16 A VGND VNB VPB VPWR X
.ends

* Black-box entry subcircuit for sky130_fd_sc_hd__clkinv_8 abstract view
.subckt sky130_fd_sc_hd__clkinv_8 A VGND VNB VPB VPWR Y
.ends

* Black-box entry subcircuit for sky130_fd_sc_hd__inv_12 abstract view
.subckt sky130_fd_sc_hd__inv_12 A VGND VNB VPB VPWR Y
.ends

* Black-box entry subcircuit for sky130_fd_sc_hd__clkinvlp_4 abstract view
.subckt sky130_fd_sc_hd__clkinvlp_4 A VGND VNB VPB VPWR Y
.ends

* Black-box entry subcircuit for sky130_fd_sc_hd__dlxtn_2 abstract view
.subckt sky130_fd_sc_hd__dlxtn_2 D GATE_N VGND VNB VPB VPWR Q
.ends

* Black-box entry subcircuit for sky130_fd_sc_hd__a21boi_1 abstract view
.subckt sky130_fd_sc_hd__a21boi_1 A1 A2 B1_N VGND VNB VPB VPWR Y
.ends

* Black-box entry subcircuit for sky130_fd_sc_hd__clkinv_4 abstract view
.subckt sky130_fd_sc_hd__clkinv_4 A VGND VNB VPB VPWR Y
.ends

* Black-box entry subcircuit for sky130_fd_sc_hd__o211a_2 abstract view
.subckt sky130_fd_sc_hd__o211a_2 A1 A2 B1 C1 VGND VNB VPB VPWR X
.ends

* Black-box entry subcircuit for sky130_fd_sc_hd__inv_6 abstract view
.subckt sky130_fd_sc_hd__inv_6 A VGND VNB VPB VPWR Y
.ends

* Black-box entry subcircuit for sky130_fd_sc_hd__or4b_1 abstract view
.subckt sky130_fd_sc_hd__or4b_1 A B C D_N VGND VNB VPB VPWR X
.ends

* Black-box entry subcircuit for sky130_fd_sc_hd__a2111o_1 abstract view
.subckt sky130_fd_sc_hd__a2111o_1 A1 A2 B1 C1 D1 VGND VNB VPB VPWR X
.ends

* Black-box entry subcircuit for sky130_fd_sc_hd__or3_4 abstract view
.subckt sky130_fd_sc_hd__or3_4 A B C VGND VNB VPB VPWR X
.ends

* Black-box entry subcircuit for sky130_fd_sc_hd__nor3_1 abstract view
.subckt sky130_fd_sc_hd__nor3_1 A B C VGND VNB VPB VPWR Y
.ends

* Black-box entry subcircuit for sky130_fd_sc_hd__nor3b_1 abstract view
.subckt sky130_fd_sc_hd__nor3b_1 A B C_N VGND VNB VPB VPWR Y
.ends

* Black-box entry subcircuit for sky130_fd_sc_hd__o31ai_1 abstract view
.subckt sky130_fd_sc_hd__o31ai_1 A1 A2 A3 B1 VGND VNB VPB VPWR Y
.ends

* Black-box entry subcircuit for sky130_fd_sc_hd__o211ai_1 abstract view
.subckt sky130_fd_sc_hd__o211ai_1 A1 A2 B1 C1 VGND VNB VPB VPWR Y
.ends

* Black-box entry subcircuit for sky130_fd_sc_hd__xor2_2 abstract view
.subckt sky130_fd_sc_hd__xor2_2 A B VGND VNB VPB VPWR X
.ends

* Black-box entry subcircuit for sky130_fd_sc_hd__inv_16 abstract view
.subckt sky130_fd_sc_hd__inv_16 A VGND VNB VPB VPWR Y
.ends

* Black-box entry subcircuit for sky130_fd_sc_hd__a22oi_1 abstract view
.subckt sky130_fd_sc_hd__a22oi_1 A1 A2 B1 B2 VGND VNB VPB VPWR Y
.ends

* Black-box entry subcircuit for sky130_fd_sc_hd__a21boi_2 abstract view
.subckt sky130_fd_sc_hd__a21boi_2 A1 A2 B1_N VGND VNB VPB VPWR Y
.ends

* Black-box entry subcircuit for sky130_fd_sc_hd__and4b_1 abstract view
.subckt sky130_fd_sc_hd__and4b_1 A_N B C D VGND VNB VPB VPWR X
.ends

* Black-box entry subcircuit for sky130_fd_sc_hd__or3_2 abstract view
.subckt sky130_fd_sc_hd__or3_2 A B C VGND VNB VPB VPWR X
.ends

* Black-box entry subcircuit for sky130_fd_sc_hd__a211oi_1 abstract view
.subckt sky130_fd_sc_hd__a211oi_1 A1 A2 B1 C1 VGND VNB VPB VPWR Y
.ends

* Black-box entry subcircuit for sky130_fd_sc_hd__a221o_4 abstract view
.subckt sky130_fd_sc_hd__a221o_4 A1 A2 B1 B2 C1 VGND VNB VPB VPWR X
.ends

* Black-box entry subcircuit for sky130_fd_sc_hd__a31o_4 abstract view
.subckt sky130_fd_sc_hd__a31o_4 A1 A2 A3 B1 VGND VNB VPB VPWR X
.ends

* Black-box entry subcircuit for sky130_fd_sc_hd__nor2b_1 abstract view
.subckt sky130_fd_sc_hd__nor2b_1 A B_N VGND VNB VPB VPWR Y
.ends

* Black-box entry subcircuit for sky130_fd_sc_hd__nand2_4 abstract view
.subckt sky130_fd_sc_hd__nand2_4 A B VGND VNB VPB VPWR Y
.ends

* Black-box entry subcircuit for sky130_fd_sc_hd__nand4_1 abstract view
.subckt sky130_fd_sc_hd__nand4_1 A B C D VGND VNB VPB VPWR Y
.ends

* Black-box entry subcircuit for sky130_fd_sc_hd__nor2_8 abstract view
.subckt sky130_fd_sc_hd__nor2_8 A B VGND VNB VPB VPWR Y
.ends

* Black-box entry subcircuit for sky130_fd_sc_hd__clkinvlp_2 abstract view
.subckt sky130_fd_sc_hd__clkinvlp_2 A VGND VNB VPB VPWR Y
.ends

* Black-box entry subcircuit for sky130_fd_sc_hd__o2111ai_2 abstract view
.subckt sky130_fd_sc_hd__o2111ai_2 A1 A2 B1 C1 D1 VGND VNB VPB VPWR Y
.ends

* Black-box entry subcircuit for sky130_fd_sc_hd__o311a_1 abstract view
.subckt sky130_fd_sc_hd__o311a_1 A1 A2 A3 B1 C1 VGND VNB VPB VPWR X
.ends

* Black-box entry subcircuit for sky130_fd_sc_hd__dfxtp_2 abstract view
.subckt sky130_fd_sc_hd__dfxtp_2 CLK D VGND VNB VPB VPWR Q
.ends

* Black-box entry subcircuit for sky130_fd_sc_hd__a21oi_4 abstract view
.subckt sky130_fd_sc_hd__a21oi_4 A1 A2 B1 VGND VNB VPB VPWR Y
.ends

* Black-box entry subcircuit for sky130_fd_sc_hd__a22o_4 abstract view
.subckt sky130_fd_sc_hd__a22o_4 A1 A2 B1 B2 VGND VNB VPB VPWR X
.ends

* Black-box entry subcircuit for sky130_fd_sc_hd__or4b_2 abstract view
.subckt sky130_fd_sc_hd__or4b_2 A B C D_N VGND VNB VPB VPWR X
.ends

* Black-box entry subcircuit for sky130_fd_sc_hd__o32a_2 abstract view
.subckt sky130_fd_sc_hd__o32a_2 A1 A2 A3 B1 B2 VGND VNB VPB VPWR X
.ends

* Black-box entry subcircuit for sky130_fd_sc_hd__inv_4 abstract view
.subckt sky130_fd_sc_hd__inv_4 A VGND VNB VPB VPWR Y
.ends

* Black-box entry subcircuit for sky130_fd_sc_hd__a31oi_4 abstract view
.subckt sky130_fd_sc_hd__a31oi_4 A1 A2 A3 B1 VGND VNB VPB VPWR Y
.ends

* Black-box entry subcircuit for sky130_fd_sc_hd__conb_1 abstract view
.subckt sky130_fd_sc_hd__conb_1 VGND VNB VPB VPWR HI LO
.ends

* Black-box entry subcircuit for sky130_fd_sc_hd__nor2b_2 abstract view
.subckt sky130_fd_sc_hd__nor2b_2 A B_N VGND VNB VPB VPWR Y
.ends

* Black-box entry subcircuit for sky130_fd_sc_hd__nor4_4 abstract view
.subckt sky130_fd_sc_hd__nor4_4 A B C D VGND VNB VPB VPWR Y
.ends

.subckt Main VGND VPWR an[0] an[1] an[2] an[3] an[4] an[5] an[6] an[7] clk cx[0] cx[1]
+ cx[2] cx[3] cx[4] cx[5] cx[6] cx[7] next rst
X_3086_ reg_file.memory\[8\]\[25\] reg_file.memory\[9\]\[25\] _0640_ VGND VGND VPWR
+ VPWR _0751_ sky130_fd_sc_hd__mux2_1
X_3155_ _0817_ _0819_ _0664_ VGND VGND VPWR VPWR _0820_ sky130_fd_sc_hd__mux2_1
XTAP_TAPCELL_ROW_37_412 VGND VPWR sky130_fd_sc_hd__tapvpwrvgnd_1
XFILLER_0_27_60 VGND VGND VPWR VPWR sky130_fd_sc_hd__fill_1
X_5727_ _2296_ seven_seg_conv.digit_counter\[2\] VGND VGND VPWR VPWR _2867_ sky130_fd_sc_hd__nand2_1
XFILLER_0_76_111 VGND VGND VPWR VPWR sky130_fd_sc_hd__fill_1
X_2939_ _0576_ _0577_ _0569_ VGND VGND VPWR VPWR _0604_ sky130_fd_sc_hd__o21ai_4
X_3988_ _0017_ _0018_ _0019_ VGND VGND VPWR VPWR _1640_ sky130_fd_sc_hd__and3b_1
XTAP_TAPCELL_ROW_20_312 VGND VPWR sky130_fd_sc_hd__tapvpwrvgnd_1
X_5589_ _1330_ _2583_ VGND VGND VPWR VPWR _2795_ sky130_fd_sc_hd__nor2_1
X_4609_ _0755_ _2218_ _0756_ VGND VGND VPWR VPWR _2229_ sky130_fd_sc_hd__o21ba_1
X_5658_ reg_file.memory\[2\]\[0\] VGND VGND VPWR VPWR _2832_ sky130_fd_sc_hd__clkbuf_1
XFILLER_0_32_247 VGND VGND VPWR VPWR sky130_fd_sc_hd__fill_2
XFILLER_0_7_81 VPWR VGND VPWR VGND sky130_ef_sc_hd__decap_12
XTAP_TAPCELL_ROW_43_448 VGND VPWR sky130_fd_sc_hd__tapvpwrvgnd_1
XFILLER_0_64_69 VGND VGND VPWR VPWR sky130_fd_sc_hd__decap_6
XFILLER_0_80_46 VGND VGND VPWR VPWR sky130_fd_sc_hd__fill_1
XFILLER_0_73_169 VPWR VGND VPWR VGND sky130_ef_sc_hd__decap_12
X_4960_ alu.ALUResult\[25\] VGND VGND VPWR VPWR _2461_ sky130_fd_sc_hd__dlymetal6s2s_1
X_4891_ _2414_ VGND VGND VPWR VPWR _0111_ sky130_fd_sc_hd__clkbuf_1
X_3842_ _1362_ _1497_ VGND VGND VPWR VPWR _1498_ sky130_fd_sc_hd__xnor2_1
X_3911_ _1560_ _1562_ _1566_ VGND VGND VPWR VPWR _1567_ sky130_fd_sc_hd__a21o_1
XFILLER_0_89_88 VGND VGND VPWR VPWR sky130_fd_sc_hd__decap_6
XFILLER_0_89_55 VGND VGND VPWR VPWR sky130_fd_sc_hd__fill_1
XFILLER_0_89_11 VGND VGND VPWR VPWR sky130_fd_sc_hd__fill_1
X_5512_ reg_file.memory\[1\]\[28\] VGND VGND VPWR VPWR _2754_ sky130_fd_sc_hd__clkbuf_1
X_5443_ _2719_ VGND VGND VPWR VPWR _0358_ sky130_fd_sc_hd__clkbuf_1
X_5374_ _2682_ VGND VGND VPWR VPWR _0326_ sky130_fd_sc_hd__clkbuf_1
XFILLER_0_14_203 VGND VGND VPWR VPWR sky130_fd_sc_hd__fill_2
XFILLER_0_14_269 VGND VGND VPWR VPWR sky130_fd_sc_hd__fill_1
X_3773_ _1419_ _1425_ _1422_ VGND VGND VPWR VPWR _1429_ sky130_fd_sc_hd__a21o_1
X_4187_ _1679_ _1774_ VGND VGND VPWR VPWR _1832_ sky130_fd_sc_hd__nand2_1
X_4325_ _1814_ _1853_ _1737_ VGND VGND VPWR VPWR _1966_ sky130_fd_sc_hd__mux2_1
X_4256_ alu.ALUControl\[1\] alu.ALUControl\[0\] VGND VGND VPWR VPWR _1900_ sky130_fd_sc_hd__nand2_1
XFILLER_0_1_196 VGND VGND VPWR VPWR sky130_fd_sc_hd__fill_2
X_3207_ reg_file.memory\[0\]\[17\] reg_file.memory\[1\]\[17\] _0592_ VGND VGND VPWR
+ VPWR _0872_ sky130_fd_sc_hd__mux2_1
XFILLER_0_22_291 VGND VGND VPWR VPWR sky130_fd_sc_hd__decap_6
X_3069_ reg_file.memory\[8\]\[26\] reg_file.memory\[9\]\[26\] _0641_ VGND VGND VPWR
+ VPWR _0734_ sky130_fd_sc_hd__mux2_1
X_3138_ _0802_ reg_file.memory\[10\]\[22\] _0649_ VGND VGND VPWR VPWR _0803_ sky130_fd_sc_hd__mux2_1
XFILLER_0_64_103 VGND VGND VPWR VPWR sky130_fd_sc_hd__decap_8
XFILLER_0_49_199 VGND VGND VPWR VPWR sky130_fd_sc_hd__fill_2
XFILLER_0_49_177 VGND VGND VPWR VPWR sky130_fd_sc_hd__decap_8
XTAP_TAPCELL_ROW_40_429 VGND VPWR sky130_fd_sc_hd__tapvpwrvgnd_1
XFILLER_0_9_252 VGND VGND VPWR VPWR sky130_fd_sc_hd__fill_1
XFILLER_0_20_206 VGND VGND VPWR VPWR sky130_fd_sc_hd__fill_1
XFILLER_0_18_29 VGND VGND VPWR VPWR sky130_fd_sc_hd__fill_2
XTAP_TAPCELL_ROW_79_665 VGND VPWR sky130_fd_sc_hd__tapvpwrvgnd_1
XFILLER_0_75_57 VGND VGND VPWR VPWR sky130_fd_sc_hd__fill_2
XFILLER_0_75_24 VGND VGND VPWR VPWR sky130_fd_sc_hd__fill_2
X_4041_ _1686_ VGND VGND VPWR VPWR _1687_ sky130_fd_sc_hd__clkbuf_4
X_4110_ _0997_ _1669_ VGND VGND VPWR VPWR _1756_ sky130_fd_sc_hd__nand2_1
X_5090_ _2448_ reg_file.memory\[6\]\[19\] _2523_ VGND VGND VPWR VPWR _2533_ sky130_fd_sc_hd__mux2_1
XFILLER_0_78_217 VPWR VGND VPWR VGND sky130_ef_sc_hd__decap_12
X_5992_ clknet_leaf_16_clk _0227_ VGND VGND VPWR VPWR reg_file.memory\[7\]\[22\] sky130_fd_sc_hd__dfxtp_1
X_4943_ _2449_ VGND VGND VPWR VPWR _0128_ sky130_fd_sc_hd__clkbuf_1
X_4874_ clk_div.slow_clk _2302_ VGND VGND VPWR VPWR _0108_ sky130_fd_sc_hd__xnor2_1
XTAP_TAPCELL_ROW_62_565 VGND VPWR sky130_fd_sc_hd__tapvpwrvgnd_1
X_3756_ _1400_ _1402_ _1408_ _1411_ VGND VGND VPWR VPWR _1412_ sky130_fd_sc_hd__a2bb2o_1
X_3825_ _1474_ _1477_ _1480_ VGND VGND VPWR VPWR _1481_ sky130_fd_sc_hd__a21o_1
X_3687_ seven_seg_conv.digit_counter\[3\] VGND VGND VPWR VPWR _1344_ sky130_fd_sc_hd__buf_6
XFILLER_0_71_3 VGND VGND VPWR VPWR sky130_fd_sc_hd__decap_6
X_5357_ _2673_ VGND VGND VPWR VPWR _0318_ sky130_fd_sc_hd__clkbuf_1
X_5426_ _2710_ VGND VGND VPWR VPWR _0350_ sky130_fd_sc_hd__clkbuf_1
X_4239_ _1778_ _1785_ _1819_ VGND VGND VPWR VPWR _1883_ sky130_fd_sc_hd__mux2_1
X_4308_ _1108_ _1656_ VGND VGND VPWR VPWR _1950_ sky130_fd_sc_hd__nor2_1
X_5288_ _2637_ VGND VGND VPWR VPWR _0285_ sky130_fd_sc_hd__clkbuf_1
XTAP_TAPCELL_ROW_53_510 VGND VPWR sky130_fd_sc_hd__tapvpwrvgnd_1
XFILLER_0_52_128 VGND VGND VPWR VPWR sky130_fd_sc_hd__fill_1
XFILLER_0_37_169 VGND VGND VPWR VPWR sky130_fd_sc_hd__fill_2
XTAP_TAPCELL_ROW_76_646 VGND VPWR sky130_fd_sc_hd__tapvpwrvgnd_1
XFILLER_0_0_29 VGND VGND VPWR VPWR sky130_fd_sc_hd__decap_8
X_4590_ _2190_ _2211_ _1779_ VGND VGND VPWR VPWR _2212_ sky130_fd_sc_hd__mux2_1
X_3610_ _0935_ _1209_ VGND VGND VPWR VPWR _1275_ sky130_fd_sc_hd__xor2_1
XFILLER_0_28_114 VGND VGND VPWR VPWR sky130_fd_sc_hd__fill_1
XTAP_TAPCELL_ROW_16_289 VGND VPWR sky130_fd_sc_hd__tapvpwrvgnd_1
X_6260_ clk_div.slow_clk _0495_ VGND VGND VPWR VPWR net9 sky130_fd_sc_hd__dfxtp_1
XFILLER_0_86_45 VGND VGND VPWR VPWR sky130_fd_sc_hd__fill_1
X_6191_ clknet_leaf_9_clk _0426_ VGND VGND VPWR VPWR reg_file.memory\[21\]\[29\] sky130_fd_sc_hd__dfxtp_1
X_3472_ _0668_ _1132_ _1135_ _1136_ VGND VGND VPWR VPWR _1137_ sky130_fd_sc_hd__a31o_1
XFILLER_0_51_194 VPWR VGND VPWR VGND sky130_ef_sc_hd__decap_12
X_3541_ _0982_ _1204_ _1205_ VGND VGND VPWR VPWR _1206_ sky130_fd_sc_hd__a21oi_1
X_5211_ _2598_ VGND VGND VPWR VPWR _0247_ sky130_fd_sc_hd__clkbuf_1
X_4024_ _1669_ VGND VGND VPWR VPWR _1670_ sky130_fd_sc_hd__clkbuf_4
X_5073_ _2524_ VGND VGND VPWR VPWR _0183_ sky130_fd_sc_hd__clkbuf_1
X_5142_ _2432_ reg_file.memory\[7\]\[11\] _2559_ VGND VGND VPWR VPWR _2561_ sky130_fd_sc_hd__mux2_1
X_4926_ alu.ALUResult\[14\] VGND VGND VPWR VPWR _2438_ sky130_fd_sc_hd__buf_1
X_5975_ clknet_leaf_0_clk _0210_ VGND VGND VPWR VPWR reg_file.memory\[7\]\[5\] sky130_fd_sc_hd__dfxtp_1
X_4857_ _2392_ VGND VGND VPWR VPWR _0099_ sky130_fd_sc_hd__clkbuf_1
XFILLER_0_51_81 VPWR VGND VPWR VGND sky130_ef_sc_hd__decap_12
X_3739_ _1381_ _1382_ _1392_ _1374_ VGND VGND VPWR VPWR _1395_ sky130_fd_sc_hd__a2bb2o_1
X_4788_ _2357_ VGND VGND VPWR VPWR _0065_ sky130_fd_sc_hd__clkbuf_1
X_3808_ _1457_ _1460_ _1463_ VGND VGND VPWR VPWR _1464_ sky130_fd_sc_hd__a21o_1
X_5409_ _2701_ VGND VGND VPWR VPWR _0342_ sky130_fd_sc_hd__clkbuf_1
XTAP_TAPCELL_ROW_7_235 VGND VPWR sky130_fd_sc_hd__tapvpwrvgnd_1
XTAP_TAPCELL_ROW_73_627 VGND VPWR sky130_fd_sc_hd__tapvpwrvgnd_1
XFILLER_0_80_223 VGND VGND VPWR VPWR sky130_fd_sc_hd__fill_1
XFILLER_0_65_242 VGND VGND VPWR VPWR sky130_fd_sc_hd__decap_4
XFILLER_0_80_256 VGND VGND VPWR VPWR sky130_fd_sc_hd__decap_4
XFILLER_0_0_206 VGND VGND VPWR VPWR sky130_fd_sc_hd__fill_1
X_5760_ clknet_leaf_6_clk _0044_ VGND VGND VPWR VPWR clk_div.counter\[15\] sky130_fd_sc_hd__dfxtp_1
X_2972_ _0636_ VGND VGND VPWR VPWR _0637_ sky130_fd_sc_hd__clkbuf_4
X_4711_ clk_div.counter\[5\] _2308_ VGND VGND VPWR VPWR _2312_ sky130_fd_sc_hd__and2_1
X_4642_ _1797_ _2252_ _2253_ _2259_ VGND VGND VPWR VPWR _0525_ sky130_fd_sc_hd__a211o_1
X_4573_ _1271_ _1994_ _2189_ _2196_ VGND VGND VPWR VPWR _0519_ sky130_fd_sc_hd__a211o_1
XFILLER_0_16_139 VGND VGND VPWR VPWR sky130_fd_sc_hd__fill_1
X_5691_ _2848_ VGND VGND VPWR VPWR _0477_ sky130_fd_sc_hd__clkbuf_1
X_3455_ reg_file.memory\[4\]\[2\] reg_file.memory\[5\]\[2\] _0589_ VGND VGND VPWR
+ VPWR _1120_ sky130_fd_sc_hd__mux2_1
X_3524_ _1185_ _1186_ _1188_ VGND VGND VPWR VPWR _1189_ sky130_fd_sc_hd__a21o_1
X_6174_ clknet_leaf_23_clk _0409_ VGND VGND VPWR VPWR reg_file.memory\[21\]\[12\]
+ sky130_fd_sc_hd__dfxtp_1
X_6243_ clknet_leaf_19_clk _0478_ VGND VGND VPWR VPWR reg_file.memory\[2\]\[17\] sky130_fd_sc_hd__dfxtp_1
X_3386_ _0598_ _1050_ VGND VGND VPWR VPWR _1051_ sky130_fd_sc_hd__or2_1
XFILLER_0_79_334 VGND VGND VPWR VPWR sky130_fd_sc_hd__fill_2
X_5056_ _2515_ VGND VGND VPWR VPWR _0175_ sky130_fd_sc_hd__clkbuf_1
X_5125_ _2415_ reg_file.memory\[7\]\[3\] _2548_ VGND VGND VPWR VPWR _2552_ sky130_fd_sc_hd__mux2_1
XFILLER_0_34_3 VGND VGND VPWR VPWR sky130_fd_sc_hd__fill_1
XTAP_TAPCELL_ROW_4_216 VGND VPWR sky130_fd_sc_hd__tapvpwrvgnd_1
X_4007_ _0016_ _0019_ _1653_ _1645_ _1646_ VGND VGND VPWR VPWR _0006_ sky130_fd_sc_hd__a32o_1
XTAP_TAPCELL_ROW_70_608 VGND VPWR sky130_fd_sc_hd__tapvpwrvgnd_1
X_5958_ clknet_leaf_17_clk _0193_ VGND VGND VPWR VPWR reg_file.memory\[6\]\[20\] sky130_fd_sc_hd__dfxtp_1
X_4909_ _2426_ VGND VGND VPWR VPWR _0117_ sky130_fd_sc_hd__clkbuf_1
X_5889_ clknet_leaf_19_clk _0124_ VGND VGND VPWR VPWR reg_file.memory\[4\]\[15\] sky130_fd_sc_hd__dfxtp_1
XFILLER_0_89_109 VGND VGND VPWR VPWR sky130_fd_sc_hd__decap_3
XFILLER_0_38_253 VGND VGND VPWR VPWR sky130_fd_sc_hd__fill_1
X_3240_ reg_file.memory\[4\]\[15\] reg_file.memory\[5\]\[15\] _0592_ VGND VGND VPWR
+ VPWR _0905_ sky130_fd_sc_hd__mux2_1
XANTENNA_5 _2653_ VGND VGND VPWR VPWR sky130_fd_sc_hd__diode_2
XTAP_TAPCELL_ROW_49_487 VGND VPWR sky130_fd_sc_hd__tapvpwrvgnd_1
X_3171_ _0833_ _0835_ _0664_ VGND VGND VPWR VPWR _0836_ sky130_fd_sc_hd__mux2_1
X_5743_ net1 _0010_ _0027_ VGND VGND VPWR VPWR PC\[3\] sky130_fd_sc_hd__dfrtp_1
X_2955_ _0549_ PC\[1\] VGND VGND VPWR VPWR _0620_ sky130_fd_sc_hd__nand2_2
X_5812_ _0514_ _0014_ VGND VGND VPWR VPWR alu.ALUResult\[18\] sky130_fd_sc_hd__dlxtn_1
X_2886_ _0547_ _0548_ _0550_ VGND VGND VPWR VPWR _0551_ sky130_fd_sc_hd__nor3_2
X_4625_ _2071_ _2158_ _2242_ _2243_ VGND VGND VPWR VPWR _2244_ sky130_fd_sc_hd__a2bb2o_1
X_3507_ _0662_ _1171_ VGND VGND VPWR VPWR _1172_ sky130_fd_sc_hd__nand2_1
X_4556_ _1315_ _2059_ VGND VGND VPWR VPWR _2181_ sky130_fd_sc_hd__nor2_1
X_5674_ reg_file.memory\[2\]\[8\] VGND VGND VPWR VPWR _2840_ sky130_fd_sc_hd__clkbuf_1
XFILLER_0_32_94 VGND VGND VPWR VPWR sky130_fd_sc_hd__fill_1
X_4487_ _2117_ VGND VGND VPWR VPWR _2118_ sky130_fd_sc_hd__inv_2
X_5108_ _2542_ VGND VGND VPWR VPWR _0200_ sky130_fd_sc_hd__clkbuf_1
X_6157_ clknet_leaf_13_clk _0392_ VGND VGND VPWR VPWR reg_file.memory\[1\]\[27\] sky130_fd_sc_hd__dfxtp_1
X_6226_ clknet_leaf_3_clk _0461_ VGND VGND VPWR VPWR reg_file.memory\[2\]\[0\] sky130_fd_sc_hd__dfxtp_1
X_3438_ _0604_ _1101_ _1102_ _0551_ VGND VGND VPWR VPWR _1103_ sky130_fd_sc_hd__a211o_1
XFILLER_0_12_175 VGND VGND VPWR VPWR sky130_fd_sc_hd__fill_1
XFILLER_0_12_197 VGND VGND VPWR VPWR sky130_fd_sc_hd__fill_1
X_3369_ _0598_ _1033_ VGND VGND VPWR VPWR _1034_ sky130_fd_sc_hd__or2_1
XFILLER_0_67_359 VGND VGND VPWR VPWR sky130_fd_sc_hd__fill_2
X_5039_ _2505_ VGND VGND VPWR VPWR _0168_ sky130_fd_sc_hd__clkbuf_1
X_6088_ clknet_leaf_16_clk _0323_ VGND VGND VPWR VPWR reg_file.memory\[10\]\[22\]
+ sky130_fd_sc_hd__dfxtp_1
XFILLER_0_50_215 VPWR VGND VPWR VGND sky130_ef_sc_hd__decap_12
Xoutput7 net7 VGND VGND VPWR VPWR an[4] sky130_fd_sc_hd__buf_1
XFILLER_0_85_178 VPWR VGND VPWR VGND sky130_ef_sc_hd__decap_12
XFILLER_0_85_156 VPWR VGND VPWR VGND sky130_ef_sc_hd__decap_12
XTAP_TAPCELL_ROW_46_468 VGND VPWR sky130_fd_sc_hd__tapvpwrvgnd_1
XFILLER_0_78_57 VGND VGND VPWR VPWR sky130_fd_sc_hd__fill_2
X_5390_ _2401_ reg_file.memory\[15\]\[0\] _2691_ VGND VGND VPWR VPWR _2692_ sky130_fd_sc_hd__mux2_1
X_4410_ _2043_ _1200_ _2031_ _2045_ VGND VGND VPWR VPWR _2046_ sky130_fd_sc_hd__o31a_1
XFILLER_0_26_278 VGND VGND VPWR VPWR sky130_fd_sc_hd__fill_1
X_4341_ _1738_ _1882_ VGND VGND VPWR VPWR _1981_ sky130_fd_sc_hd__nand2_1
X_4272_ _1701_ _1827_ VGND VGND VPWR VPWR _1915_ sky130_fd_sc_hd__and2_1
X_3223_ reg_file.memory\[0\]\[16\] reg_file.memory\[1\]\[16\] _0592_ VGND VGND VPWR
+ VPWR _0888_ sky130_fd_sc_hd__mux2_1
X_6011_ clknet_leaf_26_clk _0246_ VGND VGND VPWR VPWR reg_file.memory\[8\]\[9\] sky130_fd_sc_hd__dfxtp_1
X_3085_ reg_file.memory\[0\]\[25\] _0749_ _0656_ VGND VGND VPWR VPWR _0750_ sky130_fd_sc_hd__mux2_1
XTAP_TAPCELL_ROW_37_413 VGND VPWR sky130_fd_sc_hd__tapvpwrvgnd_1
X_3154_ _0818_ reg_file.memory\[10\]\[21\] _0648_ VGND VGND VPWR VPWR _0819_ sky130_fd_sc_hd__mux2_1
X_5726_ _2340_ _2294_ _2866_ VGND VGND VPWR VPWR _0494_ sky130_fd_sc_hd__o21ai_1
X_2938_ _0601_ _0602_ VGND VGND VPWR VPWR _0603_ sky130_fd_sc_hd__or2_1
XFILLER_0_64_318 VGND VGND VPWR VPWR sky130_fd_sc_hd__fill_2
XFILLER_0_43_82 VGND VGND VPWR VPWR sky130_fd_sc_hd__fill_2
X_3987_ _0018_ _0019_ _1634_ _1638_ _1639_ VGND VGND VPWR VPWR _0000_ sky130_fd_sc_hd__a32o_1
XTAP_TAPCELL_ROW_20_313 VGND VPWR sky130_fd_sc_hd__tapvpwrvgnd_1
X_5657_ _2831_ VGND VGND VPWR VPWR _0460_ sky130_fd_sc_hd__clkbuf_1
X_5588_ _2794_ VGND VGND VPWR VPWR _0428_ sky130_fd_sc_hd__clkbuf_1
X_4608_ _1269_ _1994_ _2220_ _2228_ VGND VGND VPWR VPWR _0522_ sky130_fd_sc_hd__a211o_1
X_4539_ _2164_ _2165_ _1999_ VGND VGND VPWR VPWR _2166_ sky130_fd_sc_hd__and3b_1
XFILLER_0_7_93 VGND VGND VPWR VPWR sky130_fd_sc_hd__decap_8
X_6209_ clknet_leaf_22_clk _0444_ VGND VGND VPWR VPWR reg_file.memory\[25\]\[15\]
+ sky130_fd_sc_hd__dfxtp_1
XTAP_TAPCELL_ROW_43_449 VGND VPWR sky130_fd_sc_hd__tapvpwrvgnd_1
XFILLER_0_90_181 VPWR VGND VPWR VGND sky130_ef_sc_hd__decap_12
XFILLER_0_63_362 VGND VGND VPWR VPWR sky130_fd_sc_hd__fill_2
X_4890_ _2413_ reg_file.memory\[4\]\[2\] _2409_ VGND VGND VPWR VPWR _2414_ sky130_fd_sc_hd__mux2_1
X_5511_ _2753_ VGND VGND VPWR VPWR _0392_ sky130_fd_sc_hd__clkbuf_1
X_3841_ _1491_ _1493_ _1496_ VGND VGND VPWR VPWR _1497_ sky130_fd_sc_hd__a21bo_1
X_3910_ _1563_ _1564_ _1565_ VGND VGND VPWR VPWR _1566_ sky130_fd_sc_hd__mux2_1
X_3772_ _1418_ VGND VGND VPWR VPWR _1428_ sky130_fd_sc_hd__inv_2
X_4324_ _1768_ _1861_ VGND VGND VPWR VPWR _1965_ sky130_fd_sc_hd__nand2_1
X_5442_ _2461_ reg_file.memory\[15\]\[25\] _2713_ VGND VGND VPWR VPWR _2719_ sky130_fd_sc_hd__mux2_1
X_5373_ reg_file.memory\[10\]\[25\] alu.ALUResult\[25\] _2676_ VGND VGND VPWR VPWR
+ _2682_ sky130_fd_sc_hd__mux2_1
XFILLER_0_22_270 VGND VGND VPWR VPWR sky130_fd_sc_hd__fill_2
X_4186_ _1658_ _1815_ _1830_ _1708_ VGND VGND VPWR VPWR _1831_ sky130_fd_sc_hd__o22ai_2
X_4255_ _1072_ _1898_ VGND VGND VPWR VPWR _1899_ sky130_fd_sc_hd__or2b_1
X_3137_ reg_file.memory\[8\]\[22\] reg_file.memory\[9\]\[22\] _0640_ VGND VGND VPWR
+ VPWR _0802_ sky130_fd_sc_hd__mux2_1
X_3206_ reg_file.memory\[4\]\[17\] reg_file.memory\[5\]\[17\] _0592_ VGND VGND VPWR
+ VPWR _0871_ sky130_fd_sc_hd__mux2_1
XFILLER_0_49_167 VGND VGND VPWR VPWR sky130_fd_sc_hd__fill_1
X_3068_ reg_file.memory\[0\]\[26\] _0732_ _0656_ VGND VGND VPWR VPWR _0733_ sky130_fd_sc_hd__mux2_1
X_5709_ _2857_ VGND VGND VPWR VPWR _0486_ sky130_fd_sc_hd__clkbuf_1
XFILLER_0_45_362 VGND VGND VPWR VPWR sky130_fd_sc_hd__fill_2
XFILLER_0_28_318 VGND VGND VPWR VPWR sky130_fd_sc_hd__fill_1
XFILLER_0_63_181 VGND VGND VPWR VPWR sky130_fd_sc_hd__decap_3
XTAP_TAPCELL_ROW_79_666 VGND VPWR sky130_fd_sc_hd__tapvpwrvgnd_1
XFILLER_0_75_36 VGND VGND VPWR VPWR sky130_fd_sc_hd__fill_2
X_4040_ _1145_ VGND VGND VPWR VPWR _1686_ sky130_fd_sc_hd__clkbuf_4
XFILLER_0_78_229 VGND VGND VPWR VPWR sky130_fd_sc_hd__decap_8
X_5991_ clknet_leaf_16_clk _0226_ VGND VGND VPWR VPWR reg_file.memory\[7\]\[21\] sky130_fd_sc_hd__dfxtp_1
X_4942_ _2448_ reg_file.memory\[4\]\[19\] _2430_ VGND VGND VPWR VPWR _2449_ sky130_fd_sc_hd__mux2_1
X_3686_ _1343_ VGND VGND VPWR VPWR _0011_ sky130_fd_sc_hd__clkbuf_1
X_4873_ _2400_ VGND VGND VPWR VPWR _0107_ sky130_fd_sc_hd__clkbuf_1
XFILLER_0_46_159 VGND VGND VPWR VPWR sky130_fd_sc_hd__fill_1
XFILLER_0_40_83 VGND VGND VPWR VPWR sky130_fd_sc_hd__fill_1
X_3755_ _1372_ VGND VGND VPWR VPWR _1411_ sky130_fd_sc_hd__inv_2
X_3824_ _1467_ _1478_ _1479_ VGND VGND VPWR VPWR _1480_ sky130_fd_sc_hd__o21ai_1
X_4307_ _1768_ _1720_ VGND VGND VPWR VPWR _1949_ sky130_fd_sc_hd__nor2_1
XFILLER_0_64_3 VGND VGND VPWR VPWR sky130_fd_sc_hd__decap_3
X_5425_ _2444_ reg_file.memory\[15\]\[17\] _2702_ VGND VGND VPWR VPWR _2710_ sky130_fd_sc_hd__mux2_1
X_5356_ reg_file.memory\[10\]\[17\] alu.ALUResult\[17\] _2665_ VGND VGND VPWR VPWR
+ _2673_ sky130_fd_sc_hd__mux2_1
X_5287_ reg_file.memory\[0\]\[16\] VGND VGND VPWR VPWR _2637_ sky130_fd_sc_hd__clkbuf_1
XPHY_EDGE_ROW_12_Right_12 VGND VGND VPWR VPWR sky130_fd_sc_hd__decap_3
X_4238_ _1764_ _1773_ _1819_ VGND VGND VPWR VPWR _1882_ sky130_fd_sc_hd__mux2_1
X_4169_ _1810_ _1813_ _1687_ VGND VGND VPWR VPWR _1814_ sky130_fd_sc_hd__mux2_1
XPHY_EDGE_ROW_21_Right_21 VGND VGND VPWR VPWR sky130_fd_sc_hd__decap_3
XFILLER_0_77_251 VGND VGND VPWR VPWR sky130_fd_sc_hd__fill_1
XTAP_TAPCELL_ROW_53_511 VGND VPWR sky130_fd_sc_hd__tapvpwrvgnd_1
XFILLER_0_18_351 VGND VGND VPWR VPWR sky130_fd_sc_hd__fill_2
XFILLER_0_60_195 VGND VGND VPWR VPWR sky130_fd_sc_hd__fill_1
XFILLER_0_45_192 VGND VGND VPWR VPWR sky130_fd_sc_hd__fill_2
XPHY_EDGE_ROW_30_Right_30 VGND VGND VPWR VPWR sky130_fd_sc_hd__decap_3
XFILLER_0_29_29 VGND VGND VPWR VPWR sky130_fd_sc_hd__fill_2
XTAP_TAPCELL_ROW_76_647 VGND VPWR sky130_fd_sc_hd__tapvpwrvgnd_1
XFILLER_0_68_251 VGND VGND VPWR VPWR sky130_fd_sc_hd__fill_1
XFILLER_0_0_19 VGND VGND VPWR VPWR sky130_fd_sc_hd__decap_8
XFILLER_0_83_210 VGND VGND VPWR VPWR sky130_fd_sc_hd__fill_1
XFILLER_0_51_140 VPWR VGND VPWR VGND sky130_ef_sc_hd__decap_12
X_3540_ _0959_ _0966_ VGND VGND VPWR VPWR _1205_ sky130_fd_sc_hd__xnor2_1
XFILLER_0_28_148 VGND VGND VPWR VPWR sky130_fd_sc_hd__decap_3
X_6190_ clknet_leaf_9_clk _0425_ VGND VGND VPWR VPWR reg_file.memory\[21\]\[28\] sky130_fd_sc_hd__dfxtp_1
X_3471_ reg_file.memory\[25\]\[2\] _0668_ VGND VGND VPWR VPWR _1136_ sky130_fd_sc_hd__nor2_1
X_5141_ _2560_ VGND VGND VPWR VPWR _0215_ sky130_fd_sc_hd__clkbuf_1
X_5210_ reg_file.memory\[8\]\[10\] alu.ALUResult\[10\] _2597_ VGND VGND VPWR VPWR
+ _2598_ sky130_fd_sc_hd__mux2_1
X_4023_ _1668_ VGND VGND VPWR VPWR _1669_ sky130_fd_sc_hd__clkbuf_2
XFILLER_0_35_61 VGND VGND VPWR VPWR sky130_fd_sc_hd__fill_1
X_5072_ _2429_ reg_file.memory\[6\]\[10\] _2523_ VGND VGND VPWR VPWR _2524_ sky130_fd_sc_hd__mux2_1
X_4856_ reg_file.memory\[9\]\[23\] VGND VGND VPWR VPWR _2392_ sky130_fd_sc_hd__clkbuf_1
X_5974_ clknet_leaf_1_clk _0209_ VGND VGND VPWR VPWR reg_file.memory\[7\]\[4\] sky130_fd_sc_hd__dfxtp_1
X_4925_ _2437_ VGND VGND VPWR VPWR _0122_ sky130_fd_sc_hd__clkbuf_1
X_3669_ _1055_ _1326_ _1331_ VGND VGND VPWR VPWR _0015_ sky130_fd_sc_hd__o21ai_1
XFILLER_0_51_93 VGND VGND VPWR VPWR sky130_fd_sc_hd__decap_4
X_3738_ seven_seg_conv.temp\[26\] alu.ALUResult\[26\] _1346_ VGND VGND VPWR VPWR _1394_
+ sky130_fd_sc_hd__mux2_1
X_4787_ seven_seg_conv.temp\[18\] _1464_ _1635_ VGND VGND VPWR VPWR _2357_ sky130_fd_sc_hd__mux2_1
X_3807_ _1452_ _1461_ _1462_ VGND VGND VPWR VPWR _1463_ sky130_fd_sc_hd__o21ai_1
XFILLER_0_15_343 VGND VGND VPWR VPWR sky130_fd_sc_hd__fill_1
X_5408_ _2427_ reg_file.memory\[15\]\[9\] _2691_ VGND VGND VPWR VPWR _2701_ sky130_fd_sc_hd__mux2_1
X_5339_ reg_file.memory\[10\]\[9\] alu.ALUResult\[9\] _2654_ VGND VGND VPWR VPWR _2664_
+ sky130_fd_sc_hd__mux2_1
XTAP_TAPCELL_ROW_73_628 VGND VPWR sky130_fd_sc_hd__tapvpwrvgnd_1
XFILLER_0_80_235 VGND VGND VPWR VPWR sky130_fd_sc_hd__decap_6
XFILLER_0_65_276 VGND VGND VPWR VPWR sky130_fd_sc_hd__fill_1
XFILLER_0_21_335 VGND VGND VPWR VPWR sky130_fd_sc_hd__fill_1
XFILLER_0_56_27 VGND VGND VPWR VPWR sky130_fd_sc_hd__fill_1
X_4710_ _2311_ VGND VGND VPWR VPWR _0033_ sky130_fd_sc_hd__clkbuf_1
XFILLER_0_88_357 VGND VGND VPWR VPWR sky130_fd_sc_hd__fill_1
XFILLER_0_56_221 VGND VGND VPWR VPWR sky130_fd_sc_hd__fill_2
X_2971_ _0635_ VGND VGND VPWR VPWR _0636_ sky130_fd_sc_hd__clkbuf_4
X_5690_ reg_file.memory\[2\]\[16\] VGND VGND VPWR VPWR _2848_ sky130_fd_sc_hd__clkbuf_1
X_4641_ _1237_ _2257_ _2258_ _1655_ _1954_ VGND VGND VPWR VPWR _2259_ sky130_fd_sc_hd__a2111oi_1
X_4572_ _1976_ _1986_ _2195_ _2041_ VGND VGND VPWR VPWR _2196_ sky130_fd_sc_hd__o211a_1
X_3523_ _1064_ _1187_ VGND VGND VPWR VPWR _1188_ sky130_fd_sc_hd__nand2_1
XTAP_TAPCELL_ROW_12_260 VGND VPWR sky130_fd_sc_hd__tapvpwrvgnd_1
X_5124_ _2551_ VGND VGND VPWR VPWR _0207_ sky130_fd_sc_hd__clkbuf_1
X_3454_ _1118_ VGND VGND VPWR VPWR _1119_ sky130_fd_sc_hd__inv_2
X_6173_ clknet_leaf_23_clk _0408_ VGND VGND VPWR VPWR reg_file.memory\[21\]\[11\]
+ sky130_fd_sc_hd__dfxtp_1
XTAP_TAPCELL_ROW_4_217 VGND VPWR sky130_fd_sc_hd__tapvpwrvgnd_1
X_6242_ clknet_leaf_19_clk _0477_ VGND VGND VPWR VPWR reg_file.memory\[2\]\[16\] sky130_fd_sc_hd__dfxtp_1
X_3385_ reg_file.memory\[0\]\[6\] reg_file.memory\[1\]\[6\] _0590_ VGND VGND VPWR
+ VPWR _1050_ sky130_fd_sc_hd__mux2_1
XTAP_TAPCELL_ROW_70_609 VGND VPWR sky130_fd_sc_hd__tapvpwrvgnd_1
X_5055_ _2413_ reg_file.memory\[6\]\[2\] _2512_ VGND VGND VPWR VPWR _2515_ sky130_fd_sc_hd__mux2_1
X_4006_ _1624_ _0018_ VGND VGND VPWR VPWR _1653_ sky130_fd_sc_hd__xor2_1
XPHY_EDGE_ROW_9_Left_100 VGND VGND VPWR VPWR sky130_fd_sc_hd__decap_3
XFILLER_0_62_235 VGND VGND VPWR VPWR sky130_fd_sc_hd__fill_2
X_5957_ clknet_leaf_17_clk _0192_ VGND VGND VPWR VPWR reg_file.memory\[6\]\[19\] sky130_fd_sc_hd__dfxtp_1
X_4839_ _2383_ VGND VGND VPWR VPWR _0090_ sky130_fd_sc_hd__clkbuf_1
XFILLER_0_7_362 VGND VGND VPWR VPWR sky130_fd_sc_hd__fill_2
X_5888_ clknet_leaf_21_clk _0123_ VGND VGND VPWR VPWR reg_file.memory\[4\]\[14\] sky130_fd_sc_hd__dfxtp_1
X_4908_ _2425_ reg_file.memory\[4\]\[8\] _2409_ VGND VGND VPWR VPWR _2426_ sky130_fd_sc_hd__mux2_1
XFILLER_0_53_279 VGND VGND VPWR VPWR sky130_fd_sc_hd__fill_1
XANTENNA_6 _2759_ VGND VGND VPWR VPWR sky130_fd_sc_hd__diode_2
X_3170_ _0834_ reg_file.memory\[10\]\[20\] _0648_ VGND VGND VPWR VPWR _0835_ sky130_fd_sc_hd__mux2_1
XFILLER_0_88_110 VGND VGND VPWR VPWR sky130_fd_sc_hd__decap_4
X_5742_ net1 _0009_ _0026_ VGND VGND VPWR VPWR PC\[2\] sky130_fd_sc_hd__dfrtp_1
X_2885_ _0549_ PC\[1\] VGND VGND VPWR VPWR _0550_ sky130_fd_sc_hd__nor2_2
X_2954_ reg_file.memory\[15\]\[30\] _0554_ _0613_ _0618_ VGND VGND VPWR VPWR _0619_
+ sky130_fd_sc_hd__a211o_1
X_5811_ _0513_ _0014_ VGND VGND VPWR VPWR alu.ALUResult\[17\] sky130_fd_sc_hd__dlxtn_1
X_5673_ _2839_ VGND VGND VPWR VPWR _0468_ sky130_fd_sc_hd__clkbuf_1
X_4624_ _1768_ _2201_ _2064_ VGND VGND VPWR VPWR _2243_ sky130_fd_sc_hd__a21oi_1
X_4486_ _2007_ _2020_ _2116_ _1924_ VGND VGND VPWR VPWR _2117_ sky130_fd_sc_hd__o22a_1
X_4555_ _1975_ _2135_ _2179_ _1971_ _2001_ VGND VGND VPWR VPWR _2180_ sky130_fd_sc_hd__o32a_1
XPHY_EDGE_ROW_6_Right_6 VGND VGND VPWR VPWR sky130_fd_sc_hd__decap_3
X_3506_ _1170_ reg_file.memory\[10\]\[0\] _0644_ VGND VGND VPWR VPWR _1171_ sky130_fd_sc_hd__mux2_1
X_6225_ clknet_leaf_8_clk _0460_ VGND VGND VPWR VPWR reg_file.memory\[25\]\[31\] sky130_fd_sc_hd__dfxtp_1
X_5107_ _2465_ reg_file.memory\[6\]\[27\] _2534_ VGND VGND VPWR VPWR _2542_ sky130_fd_sc_hd__mux2_1
X_6156_ clknet_leaf_15_clk _0391_ VGND VGND VPWR VPWR reg_file.memory\[1\]\[26\] sky130_fd_sc_hd__dfxtp_1
X_3437_ reg_file.memory\[2\]\[3\] _0566_ _0570_ reg_file.memory\[7\]\[3\] _0578_ VGND
+ VGND VPWR VPWR _1102_ sky130_fd_sc_hd__o221a_1
X_6087_ clknet_leaf_16_clk _0322_ VGND VGND VPWR VPWR reg_file.memory\[10\]\[21\]
+ sky130_fd_sc_hd__dfxtp_1
X_3299_ _0963_ reg_file.memory\[10\]\[12\] _0646_ VGND VGND VPWR VPWR _0964_ sky130_fd_sc_hd__mux2_1
X_3368_ reg_file.memory\[0\]\[7\] reg_file.memory\[1\]\[7\] _0590_ VGND VGND VPWR
+ VPWR _1033_ sky130_fd_sc_hd__mux2_1
XFILLER_0_79_110 VGND VGND VPWR VPWR sky130_fd_sc_hd__fill_2
X_5038_ _2465_ reg_file.memory\[5\]\[27\] _2497_ VGND VGND VPWR VPWR _2505_ sky130_fd_sc_hd__mux2_1
XFILLER_0_90_363 VGND VGND VPWR VPWR sky130_fd_sc_hd__fill_1
XFILLER_0_50_227 VPWR VGND VPWR VGND sky130_ef_sc_hd__decap_12
XFILLER_0_35_279 VGND VGND VPWR VPWR sky130_fd_sc_hd__fill_1
Xoutput8 net8 VGND VGND VPWR VPWR an[5] sky130_fd_sc_hd__buf_1
Xoutput10 net10 VGND VGND VPWR VPWR an[7] sky130_fd_sc_hd__buf_1
XFILLER_0_85_113 VPWR VGND VPWR VGND sky130_ef_sc_hd__decap_12
XPHY_EDGE_ROW_59_Right_59 VGND VGND VPWR VPWR sky130_fd_sc_hd__decap_3
XTAP_TAPCELL_ROW_46_469 VGND VPWR sky130_fd_sc_hd__tapvpwrvgnd_1
X_4340_ _1768_ _1886_ VGND VGND VPWR VPWR _1980_ sky130_fd_sc_hd__nand2_1
XFILLER_0_81_363 VGND VGND VPWR VPWR sky130_fd_sc_hd__fill_1
X_4271_ _1912_ _1913_ _1733_ VGND VGND VPWR VPWR _1914_ sky130_fd_sc_hd__mux2_1
XPHY_EDGE_ROW_68_Right_68 VGND VGND VPWR VPWR sky130_fd_sc_hd__decap_3
X_3153_ reg_file.memory\[8\]\[21\] reg_file.memory\[9\]\[21\] _0639_ VGND VGND VPWR
+ VPWR _0818_ sky130_fd_sc_hd__mux2_1
X_6010_ clknet_leaf_25_clk _0245_ VGND VGND VPWR VPWR reg_file.memory\[8\]\[8\] sky130_fd_sc_hd__dfxtp_1
X_3222_ reg_file.memory\[4\]\[16\] reg_file.memory\[5\]\[16\] _0592_ VGND VGND VPWR
+ VPWR _0887_ sky130_fd_sc_hd__mux2_1
X_3084_ reg_file.memory\[5\]\[25\] _0748_ _0649_ VGND VGND VPWR VPWR _0749_ sky130_fd_sc_hd__mux2_1
XTAP_TAPCELL_ROW_37_414 VGND VPWR sky130_fd_sc_hd__tapvpwrvgnd_1
X_5725_ _2341_ net10 VGND VGND VPWR VPWR _2866_ sky130_fd_sc_hd__nand2_1
XPHY_EDGE_ROW_77_Right_77 VGND VGND VPWR VPWR sky130_fd_sc_hd__decap_3
XFILLER_0_76_179 VGND VGND VPWR VPWR sky130_fd_sc_hd__decap_4
X_2937_ reg_file.memory\[0\]\[30\] reg_file.memory\[1\]\[30\] _0594_ VGND VGND VPWR
+ VPWR _0602_ sky130_fd_sc_hd__mux2_1
X_5656_ alu.ALUResult\[31\] reg_file.memory\[25\]\[31\] _2796_ VGND VGND VPWR VPWR
+ _2831_ sky130_fd_sc_hd__mux2_1
X_4607_ _1976_ _2038_ _2227_ _2041_ VGND VGND VPWR VPWR _2228_ sky130_fd_sc_hd__o211a_1
X_3986_ _1630_ _0017_ VGND VGND VPWR VPWR _1639_ sky130_fd_sc_hd__nand2b_1
XPHY_EDGE_ROW_86_Right_86 VGND VGND VPWR VPWR sky130_fd_sc_hd__decap_3
X_4469_ _1748_ _1751_ VGND VGND VPWR VPWR _2101_ sky130_fd_sc_hd__nand2_1
X_5587_ _2367_ reg_file.memory\[21\]\[31\] _2759_ VGND VGND VPWR VPWR _2794_ sky130_fd_sc_hd__mux2_1
X_4538_ _2162_ _1309_ _2163_ VGND VGND VPWR VPWR _2165_ sky130_fd_sc_hd__or3_1
X_6208_ clknet_leaf_22_clk _0443_ VGND VGND VPWR VPWR reg_file.memory\[25\]\[14\]
+ sky130_fd_sc_hd__dfxtp_1
X_6139_ clknet_leaf_26_clk _0374_ VGND VGND VPWR VPWR reg_file.memory\[1\]\[9\] sky130_fd_sc_hd__dfxtp_1
XFILLER_0_67_113 VPWR VGND VPWR VGND sky130_ef_sc_hd__decap_12
XFILLER_0_90_193 VGND VGND VPWR VPWR sky130_fd_sc_hd__decap_3
XTAP_TAPCELL_ROW_51_494 VGND VPWR sky130_fd_sc_hd__tapvpwrvgnd_1
XFILLER_0_89_57 VGND VGND VPWR VPWR sky130_fd_sc_hd__decap_3
XFILLER_0_73_138 VGND VGND VPWR VPWR sky130_fd_sc_hd__decap_3
X_5510_ reg_file.memory\[1\]\[27\] VGND VGND VPWR VPWR _2753_ sky130_fd_sc_hd__clkbuf_1
X_3840_ _1494_ _1495_ _1487_ VGND VGND VPWR VPWR _1496_ sky130_fd_sc_hd__a21bo_1
X_3771_ _1416_ _1417_ VGND VGND VPWR VPWR _1427_ sky130_fd_sc_hd__or2_1
X_4323_ _1963_ _1839_ _1843_ _1816_ VGND VGND VPWR VPWR _1964_ sky130_fd_sc_hd__a211o_1
X_5441_ _2718_ VGND VGND VPWR VPWR _0357_ sky130_fd_sc_hd__clkbuf_1
X_5372_ _2681_ VGND VGND VPWR VPWR _0325_ sky130_fd_sc_hd__clkbuf_1
X_4185_ _1816_ _1823_ _1829_ VGND VGND VPWR VPWR _1830_ sky130_fd_sc_hd__o21ai_1
X_4254_ _1744_ _1881_ _1888_ _1897_ _1800_ VGND VGND VPWR VPWR _1898_ sky130_fd_sc_hd__o32a_1
X_3136_ reg_file.memory\[0\]\[22\] _0800_ _0656_ VGND VGND VPWR VPWR _0801_ sky130_fd_sc_hd__mux2_1
X_3067_ reg_file.memory\[5\]\[26\] _0731_ _0649_ VGND VGND VPWR VPWR _0732_ sky130_fd_sc_hd__mux2_1
X_3205_ reg_file.memory\[2\]\[17\] _0567_ _0573_ reg_file.memory\[7\]\[17\] _0580_
+ VGND VGND VPWR VPWR _0870_ sky130_fd_sc_hd__o221a_1
XFILLER_0_64_149 VGND VGND VPWR VPWR sky130_fd_sc_hd__decap_3
XFILLER_0_54_71 VGND VGND VPWR VPWR sky130_fd_sc_hd__decap_3
XFILLER_0_49_113 VGND VGND VPWR VPWR sky130_fd_sc_hd__fill_1
XFILLER_0_37_319 VGND VGND VPWR VPWR sky130_fd_sc_hd__fill_1
X_5708_ reg_file.memory\[2\]\[25\] VGND VGND VPWR VPWR _2857_ sky130_fd_sc_hd__clkbuf_1
X_5639_ _2822_ VGND VGND VPWR VPWR _0451_ sky130_fd_sc_hd__clkbuf_1
X_3969_ _1624_ VGND VGND VPWR VPWR _0017_ sky130_fd_sc_hd__buf_6
XFILLER_0_55_116 VGND VGND VPWR VPWR sky130_fd_sc_hd__decap_3
XFILLER_0_11_208 VGND VGND VPWR VPWR sky130_fd_sc_hd__fill_2
XTAP_TAPCELL_ROW_79_667 VGND VPWR sky130_fd_sc_hd__tapvpwrvgnd_1
X_4872_ reg_file.memory\[9\]\[31\] VGND VGND VPWR VPWR _2400_ sky130_fd_sc_hd__clkbuf_1
X_5990_ clknet_leaf_17_clk _0225_ VGND VGND VPWR VPWR reg_file.memory\[7\]\[20\] sky130_fd_sc_hd__dfxtp_1
X_4941_ alu.ALUResult\[19\] VGND VGND VPWR VPWR _2448_ sky130_fd_sc_hd__buf_1
XFILLER_0_24_85 VGND VGND VPWR VPWR sky130_fd_sc_hd__fill_2
XFILLER_0_24_52 VGND VGND VPWR VPWR sky130_fd_sc_hd__fill_2
X_3823_ _1465_ _1468_ _1475_ VGND VGND VPWR VPWR _1479_ sky130_fd_sc_hd__or3_1
X_3685_ _1341_ _1342_ ctrl_unit.PCWrite VGND VGND VPWR VPWR _1343_ sky130_fd_sc_hd__mux2_1
XFILLER_0_61_108 VGND VGND VPWR VPWR sky130_fd_sc_hd__decap_4
XFILLER_0_27_363 VGND VGND VPWR VPWR sky130_fd_sc_hd__fill_1
X_5424_ _2709_ VGND VGND VPWR VPWR _0349_ sky130_fd_sc_hd__clkbuf_1
XFILLER_0_6_224 VGND VGND VPWR VPWR sky130_fd_sc_hd__decap_8
XPHY_EDGE_ROW_18_Left_109 VGND VGND VPWR VPWR sky130_fd_sc_hd__decap_3
X_3754_ _1407_ _1403_ VGND VGND VPWR VPWR _1410_ sky130_fd_sc_hd__nand2_1
X_4306_ _1688_ _1731_ _1767_ VGND VGND VPWR VPWR _1948_ sky130_fd_sc_hd__mux2_1
XFILLER_0_57_3 VGND VGND VPWR VPWR sky130_fd_sc_hd__fill_2
X_4237_ _1738_ _1742_ _1880_ VGND VGND VPWR VPWR _1881_ sky130_fd_sc_hd__and3_1
X_5355_ _2672_ VGND VGND VPWR VPWR _0317_ sky130_fd_sc_hd__clkbuf_1
XFILLER_0_10_230 VGND VGND VPWR VPWR sky130_fd_sc_hd__fill_1
X_5286_ _2636_ VGND VGND VPWR VPWR _0284_ sky130_fd_sc_hd__clkbuf_1
X_3119_ reg_file.memory\[5\]\[23\] _0783_ _0649_ VGND VGND VPWR VPWR _0784_ sky130_fd_sc_hd__mux2_1
X_4168_ _1811_ _1812_ VGND VGND VPWR VPWR _1813_ sky130_fd_sc_hd__nand2_1
X_4099_ _0918_ _1697_ VGND VGND VPWR VPWR _1745_ sky130_fd_sc_hd__nand2_1
XFILLER_0_69_219 VGND VGND VPWR VPWR sky130_fd_sc_hd__decap_4
XFILLER_0_65_92 VGND VGND VPWR VPWR sky130_fd_sc_hd__decap_6
XPHY_EDGE_ROW_27_Left_118 VGND VGND VPWR VPWR sky130_fd_sc_hd__decap_3
XFILLER_0_37_116 VGND VGND VPWR VPWR sky130_fd_sc_hd__fill_1
XPHY_EDGE_ROW_36_Left_127 VGND VGND VPWR VPWR sky130_fd_sc_hd__decap_3
XTAP_TAPCELL_ROW_76_648 VGND VPWR sky130_fd_sc_hd__tapvpwrvgnd_1
XPHY_EDGE_ROW_45_Left_136 VGND VGND VPWR VPWR sky130_fd_sc_hd__decap_3
XTAP_TAPCELL_ROW_84_692 VGND VPWR sky130_fd_sc_hd__tapvpwrvgnd_1
XFILLER_0_83_222 VGND VGND VPWR VPWR sky130_fd_sc_hd__fill_2
XPHY_EDGE_ROW_54_Left_145 VGND VGND VPWR VPWR sky130_fd_sc_hd__decap_3
XFILLER_0_51_152 VGND VGND VPWR VPWR sky130_fd_sc_hd__decap_3
XFILLER_0_36_171 VGND VGND VPWR VPWR sky130_fd_sc_hd__decap_3
XPHY_EDGE_ROW_63_Left_154 VGND VGND VPWR VPWR sky130_fd_sc_hd__decap_3
X_3470_ _0662_ _1134_ VGND VGND VPWR VPWR _1135_ sky130_fd_sc_hd__nand2_1
X_5071_ _2511_ VGND VGND VPWR VPWR _2523_ sky130_fd_sc_hd__clkbuf_4
X_5140_ _2429_ reg_file.memory\[7\]\[10\] _2559_ VGND VGND VPWR VPWR _2560_ sky130_fd_sc_hd__mux2_1
X_4022_ _1663_ _1665_ _1666_ _1667_ VGND VGND VPWR VPWR _1668_ sky130_fd_sc_hd__and4_1
X_5973_ clknet_leaf_1_clk _0208_ VGND VGND VPWR VPWR reg_file.memory\[7\]\[3\] sky130_fd_sc_hd__dfxtp_1
XFILLER_0_74_211 VGND VGND VPWR VPWR sky130_fd_sc_hd__fill_1
XPHY_EDGE_ROW_72_Left_163 VGND VGND VPWR VPWR sky130_fd_sc_hd__decap_3
XFILLER_0_59_241 VGND VGND VPWR VPWR sky130_fd_sc_hd__decap_3
X_4855_ _2391_ VGND VGND VPWR VPWR _0098_ sky130_fd_sc_hd__clkbuf_1
X_4786_ _2340_ seven_seg_conv.temp\[17\] _2356_ VGND VGND VPWR VPWR _0064_ sky130_fd_sc_hd__a21o_1
X_3806_ _1444_ _1458_ VGND VGND VPWR VPWR _1462_ sky130_fd_sc_hd__or2_1
XTAP_TAPCELL_ROW_15_280 VGND VPWR sky130_fd_sc_hd__tapvpwrvgnd_1
X_4924_ _2436_ reg_file.memory\[4\]\[13\] _2430_ VGND VGND VPWR VPWR _2437_ sky130_fd_sc_hd__mux2_1
X_3668_ _1328_ _1330_ _1055_ VGND VGND VPWR VPWR _1331_ sky130_fd_sc_hd__o21ai_1
X_3599_ _0790_ _1226_ VGND VGND VPWR VPWR _1264_ sky130_fd_sc_hd__or2b_1
X_5407_ _2700_ VGND VGND VPWR VPWR _0341_ sky130_fd_sc_hd__clkbuf_1
X_3737_ _1374_ _1392_ VGND VGND VPWR VPWR _1393_ sky130_fd_sc_hd__xnor2_1
XPHY_EDGE_ROW_81_Left_172 VGND VGND VPWR VPWR sky130_fd_sc_hd__decap_3
X_5338_ _2663_ VGND VGND VPWR VPWR _0309_ sky130_fd_sc_hd__clkbuf_1
X_5269_ reg_file.memory\[0\]\[7\] VGND VGND VPWR VPWR _2628_ sky130_fd_sc_hd__clkbuf_1
XPHY_EDGE_ROW_90_Left_181 VGND VGND VPWR VPWR sky130_fd_sc_hd__decap_3
XTAP_TAPCELL_ROW_73_629 VGND VPWR sky130_fd_sc_hd__tapvpwrvgnd_1
XFILLER_0_65_222 VGND VGND VPWR VPWR sky130_fd_sc_hd__fill_2
XFILLER_0_33_185 VGND VGND VPWR VPWR sky130_fd_sc_hd__fill_1
XPHY_EDGE_ROW_3_Left_94 VGND VGND VPWR VPWR sky130_fd_sc_hd__decap_3
XFILLER_0_71_225 VGND VGND VPWR VPWR sky130_fd_sc_hd__fill_1
X_2970_ _0634_ VGND VGND VPWR VPWR _0635_ sky130_fd_sc_hd__clkbuf_4
X_4640_ _1237_ _2257_ VGND VGND VPWR VPWR _2258_ sky130_fd_sc_hd__nor2_1
X_4571_ _1992_ _2135_ _2194_ VGND VGND VPWR VPWR _2195_ sky130_fd_sc_hd__or3b_1
X_3522_ _1056_ _1063_ VGND VGND VPWR VPWR _1187_ sky130_fd_sc_hd__or2_1
X_3453_ _0668_ _1113_ _1116_ _1117_ VGND VGND VPWR VPWR _1118_ sky130_fd_sc_hd__a31o_2
XFILLER_0_24_185 VGND VGND VPWR VPWR sky130_fd_sc_hd__fill_2
XFILLER_0_24_141 VGND VGND VPWR VPWR sky130_fd_sc_hd__fill_1
XTAP_TAPCELL_ROW_12_261 VGND VPWR sky130_fd_sc_hd__tapvpwrvgnd_1
X_6241_ clknet_leaf_21_clk _0476_ VGND VGND VPWR VPWR reg_file.memory\[2\]\[15\] sky130_fd_sc_hd__dfxtp_1
X_5054_ _2514_ VGND VGND VPWR VPWR _0174_ sky130_fd_sc_hd__clkbuf_1
X_5123_ _2413_ reg_file.memory\[7\]\[2\] _2548_ VGND VGND VPWR VPWR _2551_ sky130_fd_sc_hd__mux2_1
X_6172_ clknet_leaf_23_clk _0407_ VGND VGND VPWR VPWR reg_file.memory\[21\]\[10\]
+ sky130_fd_sc_hd__dfxtp_1
X_3384_ reg_file.memory\[4\]\[6\] reg_file.memory\[5\]\[6\] _0590_ VGND VGND VPWR
+ VPWR _1049_ sky130_fd_sc_hd__mux2_1
XFILLER_0_62_82 VGND VGND VPWR VPWR sky130_fd_sc_hd__fill_2
XFILLER_0_47_211 VGND VGND VPWR VPWR sky130_fd_sc_hd__fill_1
XFILLER_0_46_83 VGND VGND VPWR VPWR sky130_fd_sc_hd__fill_1
XFILLER_0_46_72 VGND VGND VPWR VPWR sky130_fd_sc_hd__decap_6
XFILLER_0_1_63 VGND VGND VPWR VPWR sky130_fd_sc_hd__decap_4
X_4005_ _1650_ _1651_ _1652_ _1649_ VGND VGND VPWR VPWR _0005_ sky130_fd_sc_hd__a211o_1
X_5956_ clknet_leaf_18_clk _0191_ VGND VGND VPWR VPWR reg_file.memory\[6\]\[18\] sky130_fd_sc_hd__dfxtp_1
XFILLER_0_47_277 VGND VGND VPWR VPWR sky130_fd_sc_hd__decap_3
X_4907_ alu.ALUResult\[8\] VGND VGND VPWR VPWR _2425_ sky130_fd_sc_hd__buf_1
X_4769_ _2347_ VGND VGND VPWR VPWR _0056_ sky130_fd_sc_hd__clkbuf_1
X_4838_ reg_file.memory\[9\]\[14\] VGND VGND VPWR VPWR _2383_ sky130_fd_sc_hd__clkbuf_1
X_5887_ clknet_leaf_21_clk _0122_ VGND VGND VPWR VPWR reg_file.memory\[4\]\[13\] sky130_fd_sc_hd__dfxtp_1
XFILLER_0_70_291 VGND VGND VPWR VPWR sky130_fd_sc_hd__fill_2
XFILLER_0_30_144 VGND VGND VPWR VPWR sky130_fd_sc_hd__fill_1
XFILLER_0_85_328 VGND VGND VPWR VPWR sky130_fd_sc_hd__fill_1
XFILLER_0_38_266 VGND VGND VPWR VPWR sky130_fd_sc_hd__fill_2
XFILLER_0_53_225 VGND VGND VPWR VPWR sky130_fd_sc_hd__fill_1
XANTENNA_7 _2511_ VGND VGND VPWR VPWR sky130_fd_sc_hd__diode_2
XFILLER_0_21_111 VGND VGND VPWR VPWR sky130_fd_sc_hd__fill_1
X_5810_ _0512_ _0014_ VGND VGND VPWR VPWR alu.ALUResult\[16\] sky130_fd_sc_hd__dlxtn_1
XFILLER_0_29_222 VGND VGND VPWR VPWR sky130_fd_sc_hd__fill_2
X_2884_ PC\[0\] VGND VGND VPWR VPWR _0549_ sky130_fd_sc_hd__buf_2
X_4623_ _1963_ _2222_ _2241_ _1768_ VGND VGND VPWR VPWR _2242_ sky130_fd_sc_hd__a211o_1
X_5741_ net1 _0008_ _0025_ VGND VGND VPWR VPWR PC\[1\] sky130_fd_sc_hd__dfrtp_4
XFILLER_0_44_225 VGND VGND VPWR VPWR sky130_fd_sc_hd__decap_3
X_2953_ _0617_ VGND VGND VPWR VPWR _0618_ sky130_fd_sc_hd__buf_2
X_5672_ reg_file.memory\[2\]\[7\] VGND VGND VPWR VPWR _2839_ sky130_fd_sc_hd__clkbuf_1
X_6224_ clknet_leaf_8_clk _0459_ VGND VGND VPWR VPWR reg_file.memory\[25\]\[30\] sky130_fd_sc_hd__dfxtp_1
X_4485_ _2062_ _2115_ _1732_ VGND VGND VPWR VPWR _2116_ sky130_fd_sc_hd__mux2_1
X_4554_ _2071_ _2086_ _2178_ _2064_ VGND VGND VPWR VPWR _2179_ sky130_fd_sc_hd__o22ai_1
X_3436_ _1099_ _1100_ _0597_ VGND VGND VPWR VPWR _1101_ sky130_fd_sc_hd__mux2_1
X_3505_ reg_file.memory\[8\]\[0\] reg_file.memory\[9\]\[0\] _0635_ VGND VGND VPWR
+ VPWR _1170_ sky130_fd_sc_hd__mux2_1
X_6155_ clknet_leaf_10_clk _0390_ VGND VGND VPWR VPWR reg_file.memory\[1\]\[25\] sky130_fd_sc_hd__dfxtp_1
X_5106_ _2541_ VGND VGND VPWR VPWR _0199_ sky130_fd_sc_hd__clkbuf_1
X_5037_ _2504_ VGND VGND VPWR VPWR _0167_ sky130_fd_sc_hd__clkbuf_1
X_6086_ clknet_leaf_17_clk _0321_ VGND VGND VPWR VPWR reg_file.memory\[10\]\[20\]
+ sky130_fd_sc_hd__dfxtp_1
X_3298_ reg_file.memory\[8\]\[12\] reg_file.memory\[9\]\[12\] _0637_ VGND VGND VPWR
+ VPWR _0963_ sky130_fd_sc_hd__mux2_1
X_3367_ reg_file.memory\[4\]\[7\] reg_file.memory\[5\]\[7\] _0590_ VGND VGND VPWR
+ VPWR _1032_ sky130_fd_sc_hd__mux2_1
X_5939_ clknet_leaf_4_clk _0174_ VGND VGND VPWR VPWR reg_file.memory\[6\]\[1\] sky130_fd_sc_hd__dfxtp_1
XFILLER_0_50_239 VPWR VGND VPWR VGND sky130_ef_sc_hd__decap_12
XFILLER_0_35_225 VGND VGND VPWR VPWR sky130_fd_sc_hd__decap_8
Xoutput9 net9 VGND VGND VPWR VPWR an[6] sky130_fd_sc_hd__buf_1
Xoutput11 net11 VGND VGND VPWR VPWR cx[1] sky130_fd_sc_hd__buf_1
XFILLER_0_85_125 VGND VGND VPWR VPWR sky130_fd_sc_hd__fill_1
XFILLER_0_81_353 VGND VGND VPWR VPWR sky130_fd_sc_hd__fill_1
X_4270_ _1806_ _1810_ _1687_ VGND VGND VPWR VPWR _1913_ sky130_fd_sc_hd__mux2_1
XFILLER_0_1_314 VGND VGND VPWR VPWR sky130_fd_sc_hd__fill_1
X_3083_ reg_file.memory\[6\]\[25\] reg_file.memory\[7\]\[25\] _0640_ VGND VGND VPWR
+ VPWR _0748_ sky130_fd_sc_hd__mux2_1
XTAP_TAPCELL_ROW_37_415 VGND VPWR sky130_fd_sc_hd__tapvpwrvgnd_1
X_3152_ reg_file.memory\[0\]\[21\] _0816_ _0655_ VGND VGND VPWR VPWR _0817_ sky130_fd_sc_hd__mux2_1
X_3221_ reg_file.memory\[2\]\[16\] _0567_ _0573_ reg_file.memory\[7\]\[16\] _0580_
+ VGND VGND VPWR VPWR _0886_ sky130_fd_sc_hd__o221a_1
XFILLER_0_76_136 VGND VGND VPWR VPWR sky130_fd_sc_hd__fill_1
X_3985_ _0018_ _1637_ _0019_ VGND VGND VPWR VPWR _1638_ sky130_fd_sc_hd__a21oi_1
XFILLER_0_87_3 VGND VGND VPWR VPWR sky130_fd_sc_hd__fill_2
X_5724_ _0576_ _2864_ _2865_ _1326_ VGND VGND VPWR VPWR _0493_ sky130_fd_sc_hd__o31a_1
X_2936_ _0600_ VGND VGND VPWR VPWR _0601_ sky130_fd_sc_hd__buf_2
X_5655_ _2830_ VGND VGND VPWR VPWR _0459_ sky130_fd_sc_hd__clkbuf_1
X_5586_ _2793_ VGND VGND VPWR VPWR _0427_ sky130_fd_sc_hd__clkbuf_1
X_4606_ _2034_ _2129_ _2221_ _2226_ VGND VGND VPWR VPWR _2227_ sky130_fd_sc_hd__or4_1
XFILLER_0_17_225 VGND VGND VPWR VPWR sky130_fd_sc_hd__fill_2
X_4468_ _1737_ _1845_ _1893_ VGND VGND VPWR VPWR _2100_ sky130_fd_sc_hd__and3_1
X_4399_ _2005_ _2035_ _1701_ VGND VGND VPWR VPWR _2036_ sky130_fd_sc_hd__mux2_1
XFILLER_0_40_294 VGND VGND VPWR VPWR sky130_fd_sc_hd__fill_2
X_4537_ _2162_ _2163_ _1309_ VGND VGND VPWR VPWR _2164_ sky130_fd_sc_hd__o21a_1
X_6207_ clknet_leaf_23_clk _0442_ VGND VGND VPWR VPWR reg_file.memory\[25\]\[13\]
+ sky130_fd_sc_hd__dfxtp_1
X_3419_ reg_file.memory\[2\]\[4\] _0566_ _0571_ reg_file.memory\[7\]\[4\] _0579_ VGND
+ VGND VPWR VPWR _1084_ sky130_fd_sc_hd__o221a_1
X_6138_ clknet_leaf_26_clk _0373_ VGND VGND VPWR VPWR reg_file.memory\[1\]\[8\] sky130_fd_sc_hd__dfxtp_1
XFILLER_0_67_125 VPWR VGND VPWR VGND sky130_ef_sc_hd__decap_12
X_6069_ clknet_leaf_27_clk _0304_ VGND VGND VPWR VPWR reg_file.memory\[10\]\[3\] sky130_fd_sc_hd__dfxtp_1
XFILLER_0_67_169 VPWR VGND VPWR VGND sky130_ef_sc_hd__decap_12
XTAP_TAPCELL_ROW_51_495 VGND VPWR sky130_fd_sc_hd__tapvpwrvgnd_1
XFILLER_0_58_147 VGND VGND VPWR VPWR sky130_fd_sc_hd__fill_1
XFILLER_0_89_25 VGND VGND VPWR VPWR sky130_fd_sc_hd__fill_1
XFILLER_0_73_128 VGND VGND VPWR VPWR sky130_fd_sc_hd__fill_1
X_5440_ _2459_ reg_file.memory\[15\]\[24\] _2713_ VGND VGND VPWR VPWR _2718_ sky130_fd_sc_hd__mux2_1
XTAP_TAPCELL_ROW_42_440 VGND VPWR sky130_fd_sc_hd__tapvpwrvgnd_1
XFILLER_0_13_54 VGND VGND VPWR VPWR sky130_fd_sc_hd__fill_2
X_3770_ _1423_ _1419_ _1425_ VGND VGND VPWR VPWR _1426_ sky130_fd_sc_hd__mux2_1
X_4253_ _1889_ _1892_ _1896_ _1708_ VGND VGND VPWR VPWR _1897_ sky130_fd_sc_hd__o22ai_2
X_4322_ _1786_ VGND VGND VPWR VPWR _1963_ sky130_fd_sc_hd__buf_2
X_5371_ reg_file.memory\[10\]\[24\] alu.ALUResult\[24\] _2676_ VGND VGND VPWR VPWR
+ _2681_ sky130_fd_sc_hd__mux2_1
X_3204_ reg_file.memory\[25\]\[18\] _0868_ _0670_ VGND VGND VPWR VPWR _0869_ sky130_fd_sc_hd__mux2_2
XFILLER_0_1_111 VGND VGND VPWR VPWR sky130_fd_sc_hd__fill_1
XFILLER_0_1_133 VPWR VGND VPWR VGND sky130_ef_sc_hd__decap_12
XFILLER_0_1_188 VGND VGND VPWR VPWR sky130_fd_sc_hd__fill_1
XFILLER_0_22_250 VGND VGND VPWR VPWR sky130_fd_sc_hd__fill_2
X_4184_ _1704_ _1828_ VGND VGND VPWR VPWR _1829_ sky130_fd_sc_hd__or2_1
X_3135_ reg_file.memory\[5\]\[22\] _0799_ _0648_ VGND VGND VPWR VPWR _0800_ sky130_fd_sc_hd__mux2_1
X_3066_ reg_file.memory\[6\]\[26\] reg_file.memory\[7\]\[26\] _0640_ VGND VGND VPWR
+ VPWR _0731_ sky130_fd_sc_hd__mux2_1
XFILLER_0_38_73 VGND VGND VPWR VPWR sky130_fd_sc_hd__fill_2
X_2919_ _0540_ _0549_ PC\[4\] VGND VGND VPWR VPWR _0584_ sky130_fd_sc_hd__a21bo_1
X_5707_ _2856_ VGND VGND VPWR VPWR _0485_ sky130_fd_sc_hd__clkbuf_1
XFILLER_0_49_158 VGND VGND VPWR VPWR sky130_fd_sc_hd__fill_2
XFILLER_0_49_136 VGND VGND VPWR VPWR sky130_fd_sc_hd__decap_6
XFILLER_0_37_309 VGND VGND VPWR VPWR sky130_fd_sc_hd__fill_1
X_3968_ _1349_ _1622_ _1623_ VGND VGND VPWR VPWR _1624_ sky130_fd_sc_hd__a21oi_2
XFILLER_0_60_312 VGND VGND VPWR VPWR sky130_fd_sc_hd__fill_2
X_5569_ _2455_ reg_file.memory\[21\]\[22\] _2782_ VGND VGND VPWR VPWR _2785_ sky130_fd_sc_hd__mux2_1
X_5638_ _2455_ reg_file.memory\[25\]\[22\] _2819_ VGND VGND VPWR VPWR _2822_ sky130_fd_sc_hd__mux2_1
X_3899_ _1358_ _1550_ _1553_ VGND VGND VPWR VPWR _1555_ sky130_fd_sc_hd__a21o_1
XFILLER_0_28_309 VGND VGND VPWR VPWR sky130_fd_sc_hd__decap_4
XFILLER_0_55_139 VGND VGND VPWR VPWR sky130_fd_sc_hd__fill_2
XFILLER_0_78_209 VGND VGND VPWR VPWR sky130_fd_sc_hd__decap_3
X_4871_ _2399_ VGND VGND VPWR VPWR _0106_ sky130_fd_sc_hd__clkbuf_1
XFILLER_0_46_139 VGND VGND VPWR VPWR sky130_fd_sc_hd__fill_1
X_3822_ _1465_ _1468_ VGND VGND VPWR VPWR _1478_ sky130_fd_sc_hd__nor2_1
X_4940_ _2447_ VGND VGND VPWR VPWR _0127_ sky130_fd_sc_hd__clkbuf_1
X_3684_ _0560_ _0538_ _0632_ VGND VGND VPWR VPWR _1342_ sky130_fd_sc_hd__and3_2
XFILLER_0_54_183 VGND VGND VPWR VPWR sky130_fd_sc_hd__decap_4
XFILLER_0_40_85 VGND VGND VPWR VPWR sky130_fd_sc_hd__fill_2
X_5423_ _2442_ reg_file.memory\[15\]\[16\] _2702_ VGND VGND VPWR VPWR _2709_ sky130_fd_sc_hd__mux2_1
X_5354_ reg_file.memory\[10\]\[16\] alu.ALUResult\[16\] _2665_ VGND VGND VPWR VPWR
+ _2672_ sky130_fd_sc_hd__mux2_1
X_3753_ _1372_ _1408_ VGND VGND VPWR VPWR _1409_ sky130_fd_sc_hd__xnor2_1
X_4305_ _1845_ _1938_ _1939_ _1944_ _1946_ VGND VGND VPWR VPWR _1947_ sky130_fd_sc_hd__a311o_1
X_4167_ _1682_ _1695_ VGND VGND VPWR VPWR _1812_ sky130_fd_sc_hd__nand2_1
X_4236_ _1154_ _1878_ _1879_ VGND VGND VPWR VPWR _1880_ sky130_fd_sc_hd__o21ai_2
X_5285_ reg_file.memory\[0\]\[15\] VGND VGND VPWR VPWR _2636_ sky130_fd_sc_hd__clkbuf_1
X_3118_ reg_file.memory\[6\]\[23\] reg_file.memory\[7\]\[23\] _0640_ VGND VGND VPWR
+ VPWR _0783_ sky130_fd_sc_hd__mux2_1
XFILLER_0_65_82 VGND VGND VPWR VPWR sky130_fd_sc_hd__decap_6
X_3049_ reg_file.memory\[21\]\[27\] _0545_ _0626_ _0713_ VGND VGND VPWR VPWR _0714_
+ sky130_fd_sc_hd__o211ai_4
X_4098_ _1743_ VGND VGND VPWR VPWR _1744_ sky130_fd_sc_hd__buf_2
XFILLER_0_45_150 VGND VGND VPWR VPWR sky130_fd_sc_hd__decap_4
XTAP_TAPCELL_ROW_76_649 VGND VPWR sky130_fd_sc_hd__tapvpwrvgnd_1
XTAP_TAPCELL_ROW_84_693 VGND VPWR sky130_fd_sc_hd__tapvpwrvgnd_1
XFILLER_0_68_253 VGND VGND VPWR VPWR sky130_fd_sc_hd__fill_2
XFILLER_0_83_278 VGND VGND VPWR VPWR sky130_fd_sc_hd__fill_2
XFILLER_0_51_186 VGND VGND VPWR VPWR sky130_fd_sc_hd__fill_1
XFILLER_0_10_55 VGND VGND VPWR VPWR sky130_fd_sc_hd__fill_1
X_4021_ _0764_ _0782_ _0798_ _0814_ VGND VGND VPWR VPWR _1667_ sky130_fd_sc_hd__and4_1
X_5070_ _2522_ VGND VGND VPWR VPWR _0182_ sky130_fd_sc_hd__clkbuf_1
X_5972_ clknet_leaf_4_clk _0207_ VGND VGND VPWR VPWR reg_file.memory\[7\]\[2\] sky130_fd_sc_hd__dfxtp_1
X_4923_ alu.ALUResult\[13\] VGND VGND VPWR VPWR _2436_ sky130_fd_sc_hd__buf_1
XFILLER_0_74_289 VGND VGND VPWR VPWR sky130_fd_sc_hd__fill_2
X_4854_ reg_file.memory\[9\]\[22\] VGND VGND VPWR VPWR _2391_ sky130_fd_sc_hd__clkbuf_1
X_3736_ _1383_ _1386_ _1391_ VGND VGND VPWR VPWR _1392_ sky130_fd_sc_hd__a21o_1
X_3805_ _1444_ _1455_ VGND VGND VPWR VPWR _1461_ sky130_fd_sc_hd__nand2_1
X_4785_ _1467_ _1472_ _2341_ VGND VGND VPWR VPWR _2356_ sky130_fd_sc_hd__a21oi_1
XTAP_TAPCELL_ROW_15_281 VGND VPWR sky130_fd_sc_hd__tapvpwrvgnd_1
X_3667_ _0576_ _1329_ _0556_ _0558_ _0547_ VGND VGND VPWR VPWR _1330_ sky130_fd_sc_hd__a221o_1
X_3598_ _1243_ _1262_ VGND VGND VPWR VPWR _1263_ sky130_fd_sc_hd__nor2_1
XFILLER_0_42_197 VGND VGND VPWR VPWR sky130_fd_sc_hd__fill_2
X_5406_ _2425_ reg_file.memory\[15\]\[8\] _2691_ VGND VGND VPWR VPWR _2700_ sky130_fd_sc_hd__mux2_1
XFILLER_0_2_272 VGND VGND VPWR VPWR sky130_fd_sc_hd__fill_1
X_5337_ reg_file.memory\[10\]\[8\] alu.ALUResult\[8\] _2654_ VGND VGND VPWR VPWR _2663_
+ sky130_fd_sc_hd__mux2_1
X_4219_ _1674_ _1174_ VGND VGND VPWR VPWR _1864_ sky130_fd_sc_hd__or2_1
X_5199_ reg_file.memory\[8\]\[5\] alu.ALUResult\[5\] _2586_ VGND VGND VPWR VPWR _2592_
+ sky130_fd_sc_hd__mux2_1
X_5268_ _2627_ VGND VGND VPWR VPWR _0275_ sky130_fd_sc_hd__clkbuf_1
XTAP_TAPCELL_ROW_81_674 VGND VPWR sky130_fd_sc_hd__tapvpwrvgnd_1
XFILLER_0_21_337 VGND VGND VPWR VPWR sky130_fd_sc_hd__decap_3
XFILLER_0_56_29 VGND VGND VPWR VPWR sky130_fd_sc_hd__fill_2
XFILLER_0_88_304 VGND VGND VPWR VPWR sky130_fd_sc_hd__fill_1
XTAP_TAPCELL_ROW_29_362 VGND VPWR sky130_fd_sc_hd__tapvpwrvgnd_1
XFILLER_0_71_204 VGND VGND VPWR VPWR sky130_fd_sc_hd__fill_2
X_4570_ _2060_ _2103_ _2193_ _1940_ VGND VGND VPWR VPWR _2194_ sky130_fd_sc_hd__o22a_1
XFILLER_0_56_256 VGND VGND VPWR VPWR sky130_fd_sc_hd__fill_1
XFILLER_0_56_234 VGND VGND VPWR VPWR sky130_fd_sc_hd__decap_4
XTAP_TAPCELL_ROW_12_262 VGND VPWR sky130_fd_sc_hd__tapvpwrvgnd_1
X_3521_ _1072_ _1079_ VGND VGND VPWR VPWR _1186_ sky130_fd_sc_hd__or2b_1
X_3452_ reg_file.memory\[25\]\[3\] _0668_ VGND VGND VPWR VPWR _1117_ sky130_fd_sc_hd__nor2_1
X_6171_ clknet_leaf_2_clk _0406_ VGND VGND VPWR VPWR reg_file.memory\[21\]\[9\] sky130_fd_sc_hd__dfxtp_1
X_3383_ reg_file.memory\[7\]\[6\] _0674_ _0598_ reg_file.memory\[2\]\[6\] _0579_ VGND
+ VGND VPWR VPWR _1048_ sky130_fd_sc_hd__o221a_1
X_6240_ clknet_leaf_21_clk _0475_ VGND VGND VPWR VPWR reg_file.memory\[2\]\[14\] sky130_fd_sc_hd__dfxtp_1
X_5053_ _2411_ reg_file.memory\[6\]\[1\] _2512_ VGND VGND VPWR VPWR _2514_ sky130_fd_sc_hd__mux2_1
X_5122_ _2550_ VGND VGND VPWR VPWR _0206_ sky130_fd_sc_hd__clkbuf_1
X_4004_ _1643_ _1637_ VGND VGND VPWR VPWR _1652_ sky130_fd_sc_hd__nor2_1
XFILLER_0_79_337 VGND VGND VPWR VPWR sky130_fd_sc_hd__fill_2
XFILLER_0_47_245 VGND VGND VPWR VPWR sky130_fd_sc_hd__fill_2
XFILLER_0_47_223 VGND VGND VPWR VPWR sky130_fd_sc_hd__fill_1
XTAP_TAPCELL_ROW_35_398 VGND VPWR sky130_fd_sc_hd__tapvpwrvgnd_1
X_4906_ _2424_ VGND VGND VPWR VPWR _0116_ sky130_fd_sc_hd__clkbuf_1
X_5886_ clknet_leaf_24_clk _0121_ VGND VGND VPWR VPWR reg_file.memory\[4\]\[12\] sky130_fd_sc_hd__dfxtp_1
XFILLER_0_1_42 VGND VGND VPWR VPWR sky130_fd_sc_hd__fill_1
X_5955_ clknet_leaf_18_clk _0190_ VGND VGND VPWR VPWR reg_file.memory\[6\]\[17\] sky130_fd_sc_hd__dfxtp_1
X_4699_ clk_div.counter\[1\] clk_div.counter\[0\] VGND VGND VPWR VPWR _0030_ sky130_fd_sc_hd__xor2_1
XFILLER_0_62_215 VGND VGND VPWR VPWR sky130_fd_sc_hd__decap_4
X_3719_ alu.ALUResult\[31\] alu.ALUResult\[29\] VGND VGND VPWR VPWR _1375_ sky130_fd_sc_hd__and2b_1
XFILLER_0_47_267 VGND VGND VPWR VPWR sky130_fd_sc_hd__fill_1
X_4768_ seven_seg_conv.temp\[9\] _2346_ _2334_ VGND VGND VPWR VPWR _2347_ sky130_fd_sc_hd__mux2_1
X_4837_ _2382_ VGND VGND VPWR VPWR _0089_ sky130_fd_sc_hd__clkbuf_1
XFILLER_0_38_245 VGND VGND VPWR VPWR sky130_fd_sc_hd__fill_1
XFILLER_0_61_281 VGND VGND VPWR VPWR sky130_fd_sc_hd__decap_3
XFILLER_0_21_178 VGND VGND VPWR VPWR sky130_fd_sc_hd__fill_1
XFILLER_0_83_38 VGND VGND VPWR VPWR sky130_fd_sc_hd__fill_2
X_5740_ net1 _0007_ _0024_ VGND VGND VPWR VPWR PC\[0\] sky130_fd_sc_hd__dfrtp_1
XFILLER_0_76_307 VGND VGND VPWR VPWR sky130_fd_sc_hd__fill_1
X_2952_ _0616_ VGND VGND VPWR VPWR _0617_ sky130_fd_sc_hd__clkbuf_4
XFILLER_0_29_245 VGND VGND VPWR VPWR sky130_fd_sc_hd__fill_2
XFILLER_0_8_106 VGND VGND VPWR VPWR sky130_fd_sc_hd__fill_1
XFILLER_0_16_43 VGND VGND VPWR VPWR sky130_fd_sc_hd__fill_1
X_2883_ PC\[4\] PC\[3\] VGND VGND VPWR VPWR _0548_ sky130_fd_sc_hd__or2_2
X_4622_ _1819_ _1820_ _1817_ VGND VGND VPWR VPWR _2241_ sky130_fd_sc_hd__and3_1
X_4553_ _2137_ _2177_ _1789_ VGND VGND VPWR VPWR _2178_ sky130_fd_sc_hd__mux2_1
X_5671_ _2838_ VGND VGND VPWR VPWR _0467_ sky130_fd_sc_hd__clkbuf_1
X_6223_ clknet_leaf_8_clk _0458_ VGND VGND VPWR VPWR reg_file.memory\[25\]\[29\] sky130_fd_sc_hd__dfxtp_1
X_4484_ _2084_ _2114_ _1686_ VGND VGND VPWR VPWR _2115_ sky130_fd_sc_hd__mux2_1
X_6154_ clknet_leaf_12_clk _0389_ VGND VGND VPWR VPWR reg_file.memory\[1\]\[24\] sky130_fd_sc_hd__dfxtp_1
X_3504_ _1109_ _1168_ VGND VGND VPWR VPWR _1169_ sky130_fd_sc_hd__nand2_1
X_3435_ reg_file.memory\[4\]\[3\] reg_file.memory\[5\]\[3\] _0589_ VGND VGND VPWR
+ VPWR _1100_ sky130_fd_sc_hd__mux2_1
X_3366_ reg_file.memory\[2\]\[7\] _0566_ _0571_ reg_file.memory\[7\]\[7\] _0579_ VGND
+ VGND VPWR VPWR _1031_ sky130_fd_sc_hd__o221a_1
XFILLER_0_79_167 VGND VGND VPWR VPWR sky130_fd_sc_hd__fill_1
X_5105_ _2463_ reg_file.memory\[6\]\[26\] _2534_ VGND VGND VPWR VPWR _2541_ sky130_fd_sc_hd__mux2_1
X_5036_ _2463_ reg_file.memory\[5\]\[26\] _2497_ VGND VGND VPWR VPWR _2504_ sky130_fd_sc_hd__mux2_1
X_6085_ clknet_leaf_18_clk _0320_ VGND VGND VPWR VPWR reg_file.memory\[10\]\[19\]
+ sky130_fd_sc_hd__dfxtp_1
X_3297_ reg_file.memory\[0\]\[12\] _0961_ _0654_ VGND VGND VPWR VPWR _0962_ sky130_fd_sc_hd__mux2_1
XFILLER_0_67_318 VGND VGND VPWR VPWR sky130_fd_sc_hd__fill_2
X_5938_ clknet_leaf_4_clk _0173_ VGND VGND VPWR VPWR reg_file.memory\[6\]\[0\] sky130_fd_sc_hd__dfxtp_1
X_5869_ clk_div.slow_clk _0019_ VGND VGND VPWR VPWR seven_seg_conv.current_digit\[3\]
+ sky130_fd_sc_hd__dfxtp_1
Xoutput12 net12 VGND VGND VPWR VPWR cx[2] sky130_fd_sc_hd__buf_1
X_3220_ _0877_ _0884_ VGND VGND VPWR VPWR _0885_ sky130_fd_sc_hd__and2_1
X_3082_ _0746_ VGND VGND VPWR VPWR _0747_ sky130_fd_sc_hd__inv_2
X_3151_ reg_file.memory\[5\]\[21\] _0815_ _0648_ VGND VGND VPWR VPWR _0816_ sky130_fd_sc_hd__mux2_1
X_5723_ _0537_ _0631_ VGND VGND VPWR VPWR _2865_ sky130_fd_sc_hd__nor2_1
XTAP_TAPCELL_ROW_45_460 VGND VPWR sky130_fd_sc_hd__tapvpwrvgnd_1
X_3984_ _1635_ _1622_ _1623_ _1636_ VGND VGND VPWR VPWR _1637_ sky130_fd_sc_hd__a211o_1
XFILLER_0_17_204 VGND VGND VPWR VPWR sky130_fd_sc_hd__decap_3
X_2935_ _0599_ VGND VGND VPWR VPWR _0600_ sky130_fd_sc_hd__buf_2
X_5654_ _2471_ reg_file.memory\[25\]\[30\] _2796_ VGND VGND VPWR VPWR _2830_ sky130_fd_sc_hd__mux2_1
X_5585_ _2471_ reg_file.memory\[21\]\[30\] _2759_ VGND VGND VPWR VPWR _2793_ sky130_fd_sc_hd__mux2_1
X_4605_ _1768_ _2224_ _2225_ _1742_ VGND VGND VPWR VPWR _2226_ sky130_fd_sc_hd__o211a_1
XFILLER_0_40_251 VGND VGND VPWR VPWR sky130_fd_sc_hd__fill_1
X_4536_ _1217_ _2147_ VGND VGND VPWR VPWR _2163_ sky130_fd_sc_hd__and2b_1
XFILLER_0_4_197 VGND VGND VPWR VPWR sky130_fd_sc_hd__fill_2
XFILLER_0_4_175 VGND VGND VPWR VPWR sky130_fd_sc_hd__fill_1
X_4398_ _1837_ _1858_ VGND VGND VPWR VPWR _2035_ sky130_fd_sc_hd__nand2_1
XFILLER_0_68_82 VGND VGND VPWR VPWR sky130_fd_sc_hd__fill_2
X_4467_ _0935_ _2093_ _2096_ _2098_ VGND VGND VPWR VPWR _2099_ sky130_fd_sc_hd__o31a_1
X_3349_ _1006_ _1013_ VGND VGND VPWR VPWR _1014_ sky130_fd_sc_hd__nand2_1
X_3418_ reg_file.memory\[21\]\[4\] VGND VGND VPWR VPWR _1083_ sky130_fd_sc_hd__inv_2
X_6206_ clknet_leaf_22_clk _0441_ VGND VGND VPWR VPWR reg_file.memory\[25\]\[12\]
+ sky130_fd_sc_hd__dfxtp_1
X_6137_ clknet_leaf_26_clk _0372_ VGND VGND VPWR VPWR reg_file.memory\[1\]\[7\] sky130_fd_sc_hd__dfxtp_1
XTAP_TAPCELL_ROW_68_596 VGND VPWR sky130_fd_sc_hd__tapvpwrvgnd_1
XFILLER_0_67_148 VPWR VGND VPWR VGND sky130_ef_sc_hd__decap_12
XFILLER_0_67_137 VGND VGND VPWR VPWR sky130_fd_sc_hd__fill_2
X_6068_ clknet_leaf_27_clk _0303_ VGND VGND VPWR VPWR reg_file.memory\[10\]\[2\] sky130_fd_sc_hd__dfxtp_1
X_5019_ _2446_ reg_file.memory\[5\]\[18\] _2486_ VGND VGND VPWR VPWR _2495_ sky130_fd_sc_hd__mux2_1
XTAP_TAPCELL_ROW_51_496 VGND VPWR sky130_fd_sc_hd__tapvpwrvgnd_1
XFILLER_0_23_207 VGND VGND VPWR VPWR sky130_fd_sc_hd__decap_6
XFILLER_0_73_107 VGND VGND VPWR VPWR sky130_fd_sc_hd__decap_4
XFILLER_0_58_159 VPWR VGND VPWR VGND sky130_ef_sc_hd__decap_12
XTAP_TAPCELL_ROW_42_441 VGND VPWR sky130_fd_sc_hd__tapvpwrvgnd_1
XFILLER_0_39_340 VGND VGND VPWR VPWR sky130_fd_sc_hd__fill_2
X_5370_ _2680_ VGND VGND VPWR VPWR _0324_ sky130_fd_sc_hd__clkbuf_1
XFILLER_0_81_195 VGND VGND VPWR VPWR sky130_fd_sc_hd__fill_1
XFILLER_0_81_151 VGND VGND VPWR VPWR sky130_fd_sc_hd__fill_1
XFILLER_0_13_88 VGND VGND VPWR VPWR sky130_fd_sc_hd__decap_8
X_4252_ _1894_ _1895_ _1733_ VGND VGND VPWR VPWR _1896_ sky130_fd_sc_hd__mux2_1
X_4183_ _1826_ _1827_ _1786_ VGND VGND VPWR VPWR _1828_ sky130_fd_sc_hd__mux2_1
X_4321_ _1082_ _1961_ VGND VGND VPWR VPWR _1962_ sky130_fd_sc_hd__xor2_1
XFILLER_0_1_145 VGND VGND VPWR VPWR sky130_fd_sc_hd__decap_4
X_3203_ _0865_ _0867_ _0664_ VGND VGND VPWR VPWR _0868_ sky130_fd_sc_hd__mux2_1
XFILLER_0_89_284 VGND VGND VPWR VPWR sky130_fd_sc_hd__fill_2
X_3065_ _0729_ VGND VGND VPWR VPWR _0730_ sky130_fd_sc_hd__inv_2
XFILLER_0_54_95 VGND VGND VPWR VPWR sky130_fd_sc_hd__fill_1
XFILLER_0_49_104 VGND VGND VPWR VPWR sky130_fd_sc_hd__decap_8
X_3134_ reg_file.memory\[6\]\[22\] reg_file.memory\[7\]\[22\] _0639_ VGND VGND VPWR
+ VPWR _0799_ sky130_fd_sc_hd__mux2_1
X_2918_ _0540_ _0555_ VGND VGND VPWR VPWR _0583_ sky130_fd_sc_hd__nor2_1
XFILLER_0_70_83 VGND VGND VPWR VPWR sky130_fd_sc_hd__fill_1
X_5706_ reg_file.memory\[2\]\[24\] VGND VGND VPWR VPWR _2856_ sky130_fd_sc_hd__clkbuf_1
XFILLER_0_57_181 VPWR VGND VPWR VGND sky130_ef_sc_hd__decap_12
X_3967_ _1349_ seven_seg_conv.current_digit\[1\] VGND VGND VPWR VPWR _1623_ sky130_fd_sc_hd__nor2_1
X_3898_ _1358_ _1553_ _1550_ VGND VGND VPWR VPWR _1554_ sky130_fd_sc_hd__nand3_1
XFILLER_0_9_223 VGND VGND VPWR VPWR sky130_fd_sc_hd__fill_1
X_5568_ _2784_ VGND VGND VPWR VPWR _0418_ sky130_fd_sc_hd__clkbuf_1
X_4519_ _1215_ _2143_ _2146_ VGND VGND VPWR VPWR _2147_ sky130_fd_sc_hd__a21o_1
X_5637_ _2821_ VGND VGND VPWR VPWR _0450_ sky130_fd_sc_hd__clkbuf_1
X_5499_ _2747_ VGND VGND VPWR VPWR _0386_ sky130_fd_sc_hd__clkbuf_1
XFILLER_0_51_335 VGND VGND VPWR VPWR sky130_fd_sc_hd__fill_1
Xclkbuf_leaf_21_clk clknet_1_0__leaf_clk VGND VGND VPWR VPWR clknet_leaf_21_clk sky130_fd_sc_hd__clkbuf_8
XFILLER_0_75_17 VGND VGND VPWR VPWR sky130_fd_sc_hd__decap_4
XFILLER_0_24_32 VGND VGND VPWR VPWR sky130_fd_sc_hd__fill_1
XFILLER_0_24_21 VGND VGND VPWR VPWR sky130_fd_sc_hd__fill_1
X_4870_ reg_file.memory\[9\]\[30\] VGND VGND VPWR VPWR _2399_ sky130_fd_sc_hd__clkbuf_1
Xclkbuf_leaf_12_clk clknet_1_1__leaf_clk VGND VGND VPWR VPWR clknet_leaf_12_clk sky130_fd_sc_hd__clkbuf_8
XFILLER_0_39_192 VGND VGND VPWR VPWR sky130_fd_sc_hd__fill_1
X_3752_ _1403_ _1404_ _1407_ VGND VGND VPWR VPWR _1408_ sky130_fd_sc_hd__o21bai_1
X_3821_ _1363_ _1473_ _1476_ VGND VGND VPWR VPWR _1477_ sky130_fd_sc_hd__or3_1
X_4304_ _1707_ _1945_ VGND VGND VPWR VPWR _1946_ sky130_fd_sc_hd__nor2_1
X_3683_ _0586_ _1340_ VGND VGND VPWR VPWR _1341_ sky130_fd_sc_hd__nand2_1
XFILLER_0_54_195 VGND VGND VPWR VPWR sky130_fd_sc_hd__fill_1
XFILLER_0_49_51 VGND VGND VPWR VPWR sky130_fd_sc_hd__decap_4
X_5422_ _2708_ VGND VGND VPWR VPWR _0348_ sky130_fd_sc_hd__clkbuf_1
X_5353_ _2671_ VGND VGND VPWR VPWR _0316_ sky130_fd_sc_hd__clkbuf_1
X_3117_ reg_file.memory\[21\]\[23\] _0546_ _0626_ _0781_ VGND VGND VPWR VPWR _0782_
+ sky130_fd_sc_hd__o211ai_4
X_4166_ _1689_ _1692_ VGND VGND VPWR VPWR _1811_ sky130_fd_sc_hd__nand2_1
X_4235_ _1145_ _1739_ VGND VGND VPWR VPWR _1879_ sky130_fd_sc_hd__or2_1
XFILLER_0_65_61 VGND VGND VPWR VPWR sky130_fd_sc_hd__fill_1
X_5284_ _2635_ VGND VGND VPWR VPWR _0283_ sky130_fd_sc_hd__clkbuf_1
X_4097_ _1091_ _1656_ VGND VGND VPWR VPWR _1743_ sky130_fd_sc_hd__nor2_1
X_3048_ reg_file.memory\[15\]\[27\] _0554_ _0618_ _0712_ VGND VGND VPWR VPWR _0713_
+ sky130_fd_sc_hd__a211o_1
X_4999_ _2484_ VGND VGND VPWR VPWR _0149_ sky130_fd_sc_hd__clkbuf_1
XFILLER_0_5_281 VGND VGND VPWR VPWR sky130_fd_sc_hd__decap_8
XTAP_TAPCELL_ROW_84_694 VGND VPWR sky130_fd_sc_hd__tapvpwrvgnd_1
XFILLER_0_83_202 VGND VGND VPWR VPWR sky130_fd_sc_hd__decap_8
XFILLER_0_68_265 VGND VGND VPWR VPWR sky130_fd_sc_hd__fill_1
XFILLER_0_86_27 VGND VGND VPWR VPWR sky130_fd_sc_hd__fill_1
XFILLER_0_36_195 VGND VGND VPWR VPWR sky130_fd_sc_hd__fill_1
XFILLER_0_3_207 VGND VGND VPWR VPWR sky130_fd_sc_hd__fill_1
Xclkbuf_leaf_1_clk clknet_1_0__leaf_clk VGND VGND VPWR VPWR clknet_leaf_1_clk sky130_fd_sc_hd__clkbuf_8
X_4020_ _0830_ _0846_ _0862_ _0877_ VGND VGND VPWR VPWR _1666_ sky130_fd_sc_hd__and4_1
XFILLER_0_19_76 VGND VGND VPWR VPWR sky130_fd_sc_hd__fill_2
XFILLER_0_19_98 VGND VGND VPWR VPWR sky130_fd_sc_hd__fill_2
X_5971_ clknet_leaf_4_clk _0206_ VGND VGND VPWR VPWR reg_file.memory\[7\]\[1\] sky130_fd_sc_hd__dfxtp_1
XFILLER_0_59_276 VGND VGND VPWR VPWR sky130_fd_sc_hd__fill_1
XFILLER_0_59_254 VGND VGND VPWR VPWR sky130_fd_sc_hd__fill_2
X_4922_ _2435_ VGND VGND VPWR VPWR _0121_ sky130_fd_sc_hd__clkbuf_1
X_3735_ _1387_ _1390_ _1378_ VGND VGND VPWR VPWR _1391_ sky130_fd_sc_hd__o21a_1
XFILLER_0_42_132 VGND VGND VPWR VPWR sky130_fd_sc_hd__fill_2
X_4853_ _2390_ VGND VGND VPWR VPWR _0097_ sky130_fd_sc_hd__clkbuf_1
X_3804_ _1454_ _1456_ _1458_ _1459_ VGND VGND VPWR VPWR _1460_ sky130_fd_sc_hd__a2bb2o_1
X_4784_ _2355_ VGND VGND VPWR VPWR _0063_ sky130_fd_sc_hd__clkbuf_1
XTAP_TAPCELL_ROW_15_282 VGND VPWR sky130_fd_sc_hd__tapvpwrvgnd_1
XFILLER_0_15_335 VGND VGND VPWR VPWR sky130_fd_sc_hd__fill_1
X_3666_ _0549_ _0555_ VGND VGND VPWR VPWR _1329_ sky130_fd_sc_hd__nand2_1
X_3597_ _0690_ _1241_ _1242_ VGND VGND VPWR VPWR _1262_ sky130_fd_sc_hd__and3_1
X_5405_ _2699_ VGND VGND VPWR VPWR _0340_ sky130_fd_sc_hd__clkbuf_1
X_5336_ _2662_ VGND VGND VPWR VPWR _0308_ sky130_fd_sc_hd__clkbuf_1
X_5267_ reg_file.memory\[0\]\[6\] VGND VGND VPWR VPWR _2627_ sky130_fd_sc_hd__clkbuf_1
X_4218_ _1707_ _1862_ VGND VGND VPWR VPWR _1863_ sky130_fd_sc_hd__nor2_1
XFILLER_0_76_93 VPWR VGND VPWR VGND sky130_ef_sc_hd__decap_12
X_4149_ _1655_ _1794_ VGND VGND VPWR VPWR _1795_ sky130_fd_sc_hd__nor2_1
X_5198_ _2591_ VGND VGND VPWR VPWR _0241_ sky130_fd_sc_hd__clkbuf_1
XTAP_TAPCELL_ROW_81_675 VGND VPWR sky130_fd_sc_hd__tapvpwrvgnd_1
XFILLER_0_80_205 VGND VGND VPWR VPWR sky130_fd_sc_hd__fill_1
Xclkload0 clknet_1_1__leaf_clk VGND VGND VPWR VPWR clkload0/Y sky130_fd_sc_hd__inv_8
XTAP_TAPCELL_ROW_72_620 VGND VPWR sky130_fd_sc_hd__tapvpwrvgnd_1
XTAP_TAPCELL_ROW_29_363 VGND VPWR sky130_fd_sc_hd__tapvpwrvgnd_1
XFILLER_0_64_290 VGND VGND VPWR VPWR sky130_fd_sc_hd__fill_2
XFILLER_0_56_246 VGND VGND VPWR VPWR sky130_fd_sc_hd__decap_6
X_3520_ _1082_ _1184_ VGND VGND VPWR VPWR _1185_ sky130_fd_sc_hd__nand2_1
XTAP_TAPCELL_ROW_12_263 VGND VPWR sky130_fd_sc_hd__tapvpwrvgnd_1
X_5121_ _2411_ reg_file.memory\[7\]\[1\] _2548_ VGND VGND VPWR VPWR _2550_ sky130_fd_sc_hd__mux2_1
X_6170_ clknet_leaf_2_clk _0405_ VGND VGND VPWR VPWR reg_file.memory\[21\]\[8\] sky130_fd_sc_hd__dfxtp_1
X_3382_ reg_file.memory\[21\]\[6\] VGND VGND VPWR VPWR _1047_ sky130_fd_sc_hd__inv_2
X_3451_ _0663_ _1115_ VGND VGND VPWR VPWR _1116_ sky130_fd_sc_hd__nand2_1
XFILLER_0_79_316 VGND VGND VPWR VPWR sky130_fd_sc_hd__fill_2
X_5052_ _2513_ VGND VGND VPWR VPWR _0173_ sky130_fd_sc_hd__clkbuf_1
X_4003_ _0016_ _0017_ _1643_ VGND VGND VPWR VPWR _1651_ sky130_fd_sc_hd__o21a_1
XFILLER_0_62_205 VGND VGND VPWR VPWR sky130_fd_sc_hd__fill_1
XTAP_TAPCELL_ROW_35_399 VGND VPWR sky130_fd_sc_hd__tapvpwrvgnd_1
X_4905_ _2423_ reg_file.memory\[4\]\[7\] _2409_ VGND VGND VPWR VPWR _2424_ sky130_fd_sc_hd__mux2_1
XFILLER_0_1_98 VGND VGND VPWR VPWR sky130_fd_sc_hd__fill_1
X_4836_ reg_file.memory\[9\]\[13\] VGND VGND VPWR VPWR _2382_ sky130_fd_sc_hd__clkbuf_1
X_5954_ clknet_leaf_19_clk _0189_ VGND VGND VPWR VPWR reg_file.memory\[6\]\[16\] sky130_fd_sc_hd__dfxtp_1
X_5885_ clknet_leaf_24_clk _0120_ VGND VGND VPWR VPWR reg_file.memory\[4\]\[11\] sky130_fd_sc_hd__dfxtp_1
X_4698_ _2303_ VGND VGND VPWR VPWR _0029_ sky130_fd_sc_hd__clkbuf_1
X_3649_ _0822_ _1313_ VGND VGND VPWR VPWR _1314_ sky130_fd_sc_hd__nand2_1
X_3718_ _1373_ VGND VGND VPWR VPWR _1374_ sky130_fd_sc_hd__inv_2
X_4767_ _1541_ _1543_ VGND VGND VPWR VPWR _2346_ sky130_fd_sc_hd__nand2_1
XFILLER_0_7_354 VGND VGND VPWR VPWR sky130_fd_sc_hd__decap_8
X_5319_ _2510_ _2584_ VGND VGND VPWR VPWR _2653_ sky130_fd_sc_hd__nor2_4
XTAP_TAPCELL_ROW_26_344 VGND VPWR sky130_fd_sc_hd__tapvpwrvgnd_1
XFILLER_0_53_216 VGND VGND VPWR VPWR sky130_fd_sc_hd__fill_1
XFILLER_0_21_113 VGND VGND VPWR VPWR sky130_fd_sc_hd__decap_3
X_2951_ _0615_ VGND VGND VPWR VPWR _0616_ sky130_fd_sc_hd__buf_2
X_5670_ reg_file.memory\[2\]\[6\] VGND VGND VPWR VPWR _2838_ sky130_fd_sc_hd__clkbuf_1
XFILLER_0_16_88 VGND VGND VPWR VPWR sky130_fd_sc_hd__fill_1
X_2882_ _0540_ VGND VGND VPWR VPWR _0547_ sky130_fd_sc_hd__buf_2
X_4483_ _1848_ _1850_ VGND VGND VPWR VPWR _2114_ sky130_fd_sc_hd__nand2_1
X_4552_ _2156_ _2176_ _1819_ VGND VGND VPWR VPWR _2177_ sky130_fd_sc_hd__mux2_1
X_4621_ _1233_ _2239_ VGND VGND VPWR VPWR _2240_ sky130_fd_sc_hd__xor2_1
X_3503_ reg_file.memory\[0\]\[0\] _1167_ _0653_ VGND VGND VPWR VPWR _1168_ sky130_fd_sc_hd__mux2_1
X_6153_ clknet_leaf_10_clk _0388_ VGND VGND VPWR VPWR reg_file.memory\[1\]\[23\] sky130_fd_sc_hd__dfxtp_1
X_5104_ _2540_ VGND VGND VPWR VPWR _0198_ sky130_fd_sc_hd__clkbuf_1
X_6222_ clknet_leaf_9_clk _0457_ VGND VGND VPWR VPWR reg_file.memory\[25\]\[28\] sky130_fd_sc_hd__dfxtp_1
X_3365_ _1022_ _1029_ VGND VGND VPWR VPWR _1030_ sky130_fd_sc_hd__nand2_1
X_3434_ reg_file.memory\[0\]\[3\] reg_file.memory\[1\]\[3\] _0589_ VGND VGND VPWR
+ VPWR _1099_ sky130_fd_sc_hd__mux2_1
X_6084_ clknet_leaf_18_clk _0319_ VGND VGND VPWR VPWR reg_file.memory\[10\]\[18\]
+ sky130_fd_sc_hd__dfxtp_1
X_3296_ reg_file.memory\[5\]\[12\] _0960_ _0646_ VGND VGND VPWR VPWR _0961_ sky130_fd_sc_hd__mux2_1
X_5035_ _2503_ VGND VGND VPWR VPWR _0166_ sky130_fd_sc_hd__clkbuf_1
XFILLER_0_79_113 VPWR VGND VPWR VGND sky130_ef_sc_hd__decap_12
XPHY_EDGE_ROW_69_Left_160 VGND VGND VPWR VPWR sky130_fd_sc_hd__decap_3
XTAP_TAPCELL_ROW_48_480 VGND VPWR sky130_fd_sc_hd__tapvpwrvgnd_1
X_5937_ clknet_leaf_13_clk _0172_ VGND VGND VPWR VPWR reg_file.memory\[5\]\[31\] sky130_fd_sc_hd__dfxtp_1
X_5799_ _0532_ _0014_ VGND VGND VPWR VPWR alu.ALUResult\[5\] sky130_fd_sc_hd__dlxtn_1
X_5868_ clk_div.slow_clk _0018_ VGND VGND VPWR VPWR seven_seg_conv.current_digit\[2\]
+ sky130_fd_sc_hd__dfxtp_1
XFILLER_0_7_151 VGND VGND VPWR VPWR sky130_fd_sc_hd__decap_6
X_4819_ _2373_ VGND VGND VPWR VPWR _0080_ sky130_fd_sc_hd__clkbuf_1
Xoutput13 net13 VGND VGND VPWR VPWR cx[3] sky130_fd_sc_hd__buf_1
XFILLER_0_85_105 VGND VGND VPWR VPWR sky130_fd_sc_hd__decap_6
XPHY_EDGE_ROW_19_Right_19 VGND VGND VPWR VPWR sky130_fd_sc_hd__decap_3
XFILLER_0_78_39 VGND VGND VPWR VPWR sky130_fd_sc_hd__fill_2
XFILLER_0_34_293 VGND VGND VPWR VPWR sky130_fd_sc_hd__fill_1
X_3150_ reg_file.memory\[6\]\[21\] reg_file.memory\[7\]\[21\] _0639_ VGND VGND VPWR
+ VPWR _0815_ sky130_fd_sc_hd__mux2_1
XPHY_EDGE_ROW_28_Right_28 VGND VGND VPWR VPWR sky130_fd_sc_hd__decap_3
XFILLER_0_76_105 VGND VGND VPWR VPWR sky130_fd_sc_hd__decap_6
X_3081_ reg_file.memory\[21\]\[25\] _0546_ _0626_ _0745_ VGND VGND VPWR VPWR _0746_
+ sky130_fd_sc_hd__o211ai_2
XFILLER_0_49_308 VGND VGND VPWR VPWR sky130_fd_sc_hd__fill_1
XFILLER_0_43_20 VGND VGND VPWR VPWR sky130_fd_sc_hd__decap_3
XPHY_EDGE_ROW_37_Right_37 VGND VGND VPWR VPWR sky130_fd_sc_hd__decap_3
XFILLER_0_27_54 VGND VGND VPWR VPWR sky130_fd_sc_hd__fill_2
X_5653_ _2829_ VGND VGND VPWR VPWR _0458_ sky130_fd_sc_hd__clkbuf_1
X_5722_ alu.ZERO VGND VGND VPWR VPWR _2864_ sky130_fd_sc_hd__inv_2
XTAP_TAPCELL_ROW_45_461 VGND VPWR sky130_fd_sc_hd__tapvpwrvgnd_1
X_3983_ _0016_ VGND VGND VPWR VPWR _1636_ sky130_fd_sc_hd__inv_2
X_2934_ _0598_ VGND VGND VPWR VPWR _0599_ sky130_fd_sc_hd__clkbuf_2
X_5584_ _2792_ VGND VGND VPWR VPWR _0426_ sky130_fd_sc_hd__clkbuf_1
X_4604_ _1816_ _2177_ VGND VGND VPWR VPWR _2225_ sky130_fd_sc_hd__nand2_1
XPHY_EDGE_ROW_46_Right_46 VGND VGND VPWR VPWR sky130_fd_sc_hd__decap_3
X_4466_ _1902_ _2097_ VGND VGND VPWR VPWR _2098_ sky130_fd_sc_hd__nor2_1
X_4535_ _0862_ _0869_ VGND VGND VPWR VPWR _2162_ sky130_fd_sc_hd__and2b_1
XFILLER_0_7_42 VPWR VGND VPWR VGND sky130_ef_sc_hd__decap_12
X_4397_ _1889_ _1830_ VGND VGND VPWR VPWR _2034_ sky130_fd_sc_hd__nor2_1
XPHY_EDGE_ROW_55_Right_55 VGND VGND VPWR VPWR sky130_fd_sc_hd__decap_3
X_3417_ _1080_ _1081_ VGND VGND VPWR VPWR _1082_ sky130_fd_sc_hd__or2_1
X_3348_ reg_file.memory\[25\]\[9\] _1012_ _0669_ VGND VGND VPWR VPWR _1013_ sky130_fd_sc_hd__mux2_1
X_6205_ clknet_leaf_23_clk _0440_ VGND VGND VPWR VPWR reg_file.memory\[25\]\[11\]
+ sky130_fd_sc_hd__dfxtp_1
X_6067_ clknet_leaf_0_clk _0302_ VGND VGND VPWR VPWR reg_file.memory\[10\]\[1\] sky130_fd_sc_hd__dfxtp_1
X_3279_ reg_file.memory\[6\]\[13\] reg_file.memory\[7\]\[13\] _0637_ VGND VGND VPWR
+ VPWR _0944_ sky130_fd_sc_hd__mux2_1
X_6136_ clknet_leaf_0_clk _0371_ VGND VGND VPWR VPWR reg_file.memory\[1\]\[6\] sky130_fd_sc_hd__dfxtp_1
XTAP_TAPCELL_ROW_68_597 VGND VPWR sky130_fd_sc_hd__tapvpwrvgnd_1
X_5018_ _2494_ VGND VGND VPWR VPWR _0158_ sky130_fd_sc_hd__clkbuf_1
XFILLER_0_90_163 VGND VGND VPWR VPWR sky130_fd_sc_hd__decap_4
XFILLER_0_90_141 VPWR VGND VPWR VGND sky130_ef_sc_hd__decap_12
XPHY_EDGE_ROW_64_Right_64 VGND VGND VPWR VPWR sky130_fd_sc_hd__decap_3
XTAP_TAPCELL_ROW_51_497 VGND VPWR sky130_fd_sc_hd__tapvpwrvgnd_1
XPHY_EDGE_ROW_73_Right_73 VGND VGND VPWR VPWR sky130_fd_sc_hd__decap_3
XTAP_TAPCELL_ROW_59_542 VGND VPWR sky130_fd_sc_hd__tapvpwrvgnd_1
XPHY_EDGE_ROW_82_Right_82 VGND VGND VPWR VPWR sky130_fd_sc_hd__decap_3
XFILLER_0_58_138 VGND VGND VPWR VPWR sky130_fd_sc_hd__fill_2
XFILLER_0_58_127 VGND VGND VPWR VPWR sky130_fd_sc_hd__fill_1
XTAP_TAPCELL_ROW_42_442 VGND VPWR sky130_fd_sc_hd__tapvpwrvgnd_1
X_4320_ _1183_ _1956_ _1960_ VGND VGND VPWR VPWR _1961_ sky130_fd_sc_hd__o21a_1
X_4251_ _1718_ _1725_ _1701_ VGND VGND VPWR VPWR _1895_ sky130_fd_sc_hd__mux2_1
X_4182_ _1659_ _1709_ VGND VGND VPWR VPWR _1827_ sky130_fd_sc_hd__nor2_1
X_3133_ reg_file.memory\[21\]\[22\] _0546_ _0626_ _0797_ VGND VGND VPWR VPWR _0798_
+ sky130_fd_sc_hd__o211ai_2
X_3202_ _0866_ reg_file.memory\[10\]\[18\] _0648_ VGND VGND VPWR VPWR _0867_ sky130_fd_sc_hd__mux2_1
XTAP_TAPCELL_ROW_65_578 VGND VPWR sky130_fd_sc_hd__tapvpwrvgnd_1
X_3064_ reg_file.memory\[21\]\[26\] _0545_ _0727_ _0728_ _0625_ VGND VGND VPWR VPWR
+ _0729_ sky130_fd_sc_hd__o221a_2
X_5705_ _2855_ VGND VGND VPWR VPWR _0484_ sky130_fd_sc_hd__clkbuf_1
XFILLER_0_72_174 VGND VGND VPWR VPWR sky130_fd_sc_hd__decap_3
XFILLER_0_70_62 VGND VGND VPWR VPWR sky130_fd_sc_hd__fill_1
X_2917_ reg_file.memory\[2\]\[30\] _0567_ _0575_ reg_file.memory\[7\]\[30\] _0581_
+ VGND VGND VPWR VPWR _0582_ sky130_fd_sc_hd__o221a_1
XFILLER_0_57_193 VPWR VGND VPWR VGND sky130_ef_sc_hd__decap_12
X_5636_ _2453_ reg_file.memory\[25\]\[21\] _2819_ VGND VGND VPWR VPWR _2821_ sky130_fd_sc_hd__mux2_1
X_3966_ _1353_ _1621_ VGND VGND VPWR VPWR _1622_ sky130_fd_sc_hd__xnor2_1
X_3897_ _1360_ _1540_ _1544_ VGND VGND VPWR VPWR _1553_ sky130_fd_sc_hd__o21ai_1
X_4449_ _2081_ _2082_ _1999_ VGND VGND VPWR VPWR _2083_ sky130_fd_sc_hd__and3b_1
X_5567_ _2453_ reg_file.memory\[21\]\[21\] _2782_ VGND VGND VPWR VPWR _2784_ sky130_fd_sc_hd__mux2_1
X_4518_ _0877_ _0884_ VGND VGND VPWR VPWR _2146_ sky130_fd_sc_hd__and2b_1
X_5498_ reg_file.memory\[1\]\[21\] VGND VGND VPWR VPWR _2747_ sky130_fd_sc_hd__clkbuf_1
XFILLER_0_0_190 VGND VGND VPWR VPWR sky130_fd_sc_hd__fill_1
X_6119_ clknet_leaf_15_clk _0354_ VGND VGND VPWR VPWR reg_file.memory\[15\]\[21\]
+ sky130_fd_sc_hd__dfxtp_1
XFILLER_0_63_196 VGND VGND VPWR VPWR sky130_fd_sc_hd__decap_3
XFILLER_0_8_290 VGND VGND VPWR VPWR sky130_fd_sc_hd__fill_2
X_3682_ _0576_ _1339_ VGND VGND VPWR VPWR _1340_ sky130_fd_sc_hd__nand2_1
XFILLER_0_46_119 VPWR VGND VPWR VGND sky130_ef_sc_hd__decap_12
XFILLER_0_46_108 VGND VGND VPWR VPWR sky130_fd_sc_hd__decap_8
XFILLER_0_42_325 VGND VGND VPWR VPWR sky130_fd_sc_hd__fill_1
X_3751_ _1397_ _1406_ VGND VGND VPWR VPWR _1407_ sky130_fd_sc_hd__and2_1
X_3820_ _1467_ _1468_ _1475_ VGND VGND VPWR VPWR _1476_ sky130_fd_sc_hd__and3_1
X_4303_ _1702_ _1755_ _1704_ VGND VGND VPWR VPWR _1945_ sky130_fd_sc_hd__mux2_1
XFILLER_0_49_96 VGND VGND VPWR VPWR sky130_fd_sc_hd__decap_3
X_5421_ _2440_ reg_file.memory\[15\]\[15\] _2702_ VGND VGND VPWR VPWR _2708_ sky130_fd_sc_hd__mux2_1
X_5352_ reg_file.memory\[10\]\[15\] alu.ALUResult\[15\] _2665_ VGND VGND VPWR VPWR
+ _2671_ sky130_fd_sc_hd__mux2_1
X_5283_ reg_file.memory\[0\]\[14\] VGND VGND VPWR VPWR _2635_ sky130_fd_sc_hd__clkbuf_1
X_3116_ reg_file.memory\[15\]\[23\] _0554_ _0618_ _0780_ VGND VGND VPWR VPWR _0781_
+ sky130_fd_sc_hd__a211o_1
X_4165_ _1808_ _1809_ VGND VGND VPWR VPWR _1810_ sky130_fd_sc_hd__nand2_1
X_4234_ _1675_ _1787_ _1783_ VGND VGND VPWR VPWR _1878_ sky130_fd_sc_hd__o21ba_1
XFILLER_0_65_73 VGND VGND VPWR VPWR sky130_fd_sc_hd__fill_1
X_4096_ _1107_ _1741_ VGND VGND VPWR VPWR _1742_ sky130_fd_sc_hd__nor2_2
XFILLER_0_77_233 VGND VGND VPWR VPWR sky130_fd_sc_hd__fill_2
XFILLER_0_77_222 VGND VGND VPWR VPWR sky130_fd_sc_hd__fill_2
X_3047_ _0707_ _0711_ _0612_ VGND VGND VPWR VPWR _0712_ sky130_fd_sc_hd__o21a_1
X_4998_ _2425_ reg_file.memory\[5\]\[8\] _2475_ VGND VGND VPWR VPWR _2484_ sky130_fd_sc_hd__mux2_1
XFILLER_0_60_188 VGND VGND VPWR VPWR sky130_fd_sc_hd__fill_1
XFILLER_0_60_122 VGND VGND VPWR VPWR sky130_fd_sc_hd__fill_2
X_5619_ _2436_ reg_file.memory\[25\]\[13\] _2808_ VGND VGND VPWR VPWR _2812_ sky130_fd_sc_hd__mux2_1
X_3949_ _1597_ VGND VGND VPWR VPWR _1605_ sky130_fd_sc_hd__inv_2
XFILLER_0_5_260 VGND VGND VPWR VPWR sky130_fd_sc_hd__decap_6
XTAP_TAPCELL_ROW_84_695 VGND VPWR sky130_fd_sc_hd__tapvpwrvgnd_1
XPHY_EDGE_ROW_14_Left_105 VGND VGND VPWR VPWR sky130_fd_sc_hd__decap_3
XFILLER_0_83_225 VPWR VGND VPWR VGND sky130_ef_sc_hd__decap_12
XFILLER_0_51_111 VGND VGND VPWR VPWR sky130_fd_sc_hd__fill_1
XFILLER_0_51_166 VGND VGND VPWR VPWR sky130_fd_sc_hd__fill_2
XFILLER_0_10_35 VGND VGND VPWR VPWR sky130_fd_sc_hd__fill_2
XPHY_EDGE_ROW_23_Left_114 VGND VGND VPWR VPWR sky130_fd_sc_hd__decap_3
XPHY_EDGE_ROW_32_Left_123 VGND VGND VPWR VPWR sky130_fd_sc_hd__decap_3
XFILLER_0_19_66 VGND VGND VPWR VPWR sky130_fd_sc_hd__fill_1
XTAP_TAPCELL_ROW_75_640 VGND VPWR sky130_fd_sc_hd__tapvpwrvgnd_1
XFILLER_0_74_203 VGND VGND VPWR VPWR sky130_fd_sc_hd__fill_1
XFILLER_0_59_211 VPWR VGND VPWR VGND sky130_ef_sc_hd__decap_12
X_5970_ clknet_leaf_3_clk _0205_ VGND VGND VPWR VPWR reg_file.memory\[7\]\[0\] sky130_fd_sc_hd__dfxtp_1
X_4852_ reg_file.memory\[9\]\[21\] VGND VGND VPWR VPWR _2390_ sky130_fd_sc_hd__clkbuf_1
X_4921_ _2434_ reg_file.memory\[4\]\[12\] _2430_ VGND VGND VPWR VPWR _2435_ sky130_fd_sc_hd__mux2_1
X_3803_ _1444_ VGND VGND VPWR VPWR _1459_ sky130_fd_sc_hd__inv_2
X_3665_ _0539_ _0621_ _1327_ VGND VGND VPWR VPWR _1328_ sky130_fd_sc_hd__o21ai_2
XFILLER_0_51_97 VGND VGND VPWR VPWR sky130_fd_sc_hd__fill_1
X_3734_ _1388_ _1389_ _1385_ _1380_ VGND VGND VPWR VPWR _1390_ sky130_fd_sc_hd__o22a_1
XPHY_EDGE_ROW_41_Left_132 VGND VGND VPWR VPWR sky130_fd_sc_hd__decap_3
X_5404_ _2423_ reg_file.memory\[15\]\[7\] _2691_ VGND VGND VPWR VPWR _2699_ sky130_fd_sc_hd__mux2_1
XFILLER_0_27_163 VGND VGND VPWR VPWR sky130_fd_sc_hd__decap_4
XFILLER_0_27_130 VGND VGND VPWR VPWR sky130_fd_sc_hd__decap_6
X_4783_ seven_seg_conv.temp\[16\] _1481_ _2334_ VGND VGND VPWR VPWR _2355_ sky130_fd_sc_hd__mux2_1
XFILLER_0_15_347 VGND VGND VPWR VPWR sky130_fd_sc_hd__fill_2
XTAP_TAPCELL_ROW_15_283 VGND VPWR sky130_fd_sc_hd__tapvpwrvgnd_1
XFILLER_0_15_358 VGND VGND VPWR VPWR sky130_fd_sc_hd__decap_6
X_4217_ _1853_ _1861_ _1732_ VGND VGND VPWR VPWR _1862_ sky130_fd_sc_hd__mux2_1
XFILLER_0_76_61 VGND VGND VPWR VPWR sky130_fd_sc_hd__fill_1
X_3596_ _1244_ _1260_ VGND VGND VPWR VPWR _1261_ sky130_fd_sc_hd__xnor2_1
X_5266_ _2626_ VGND VGND VPWR VPWR _0274_ sky130_fd_sc_hd__clkbuf_1
X_5335_ reg_file.memory\[10\]\[7\] alu.ALUResult\[7\] _2654_ VGND VGND VPWR VPWR _2662_
+ sky130_fd_sc_hd__mux2_1
X_4079_ _1722_ _1724_ VGND VGND VPWR VPWR _1725_ sky130_fd_sc_hd__nand2_1
X_4148_ alu.ALUControl\[1\] alu.ALUControl\[0\] VGND VGND VPWR VPWR _1794_ sky130_fd_sc_hd__and2_1
XPHY_EDGE_ROW_50_Left_141 VGND VGND VPWR VPWR sky130_fd_sc_hd__decap_3
X_5197_ reg_file.memory\[8\]\[4\] alu.ALUResult\[4\] _2586_ VGND VGND VPWR VPWR _2591_
+ sky130_fd_sc_hd__mux2_1
XTAP_TAPCELL_ROW_81_676 VGND VPWR sky130_fd_sc_hd__tapvpwrvgnd_1
XFILLER_0_65_225 VGND VGND VPWR VPWR sky130_fd_sc_hd__decap_3
Xclkload1 clknet_leaf_1_clk VGND VGND VPWR VPWR clkload1/Y sky130_fd_sc_hd__bufinv_16
XFILLER_0_33_166 VGND VGND VPWR VPWR sky130_fd_sc_hd__fill_2
XTAP_TAPCELL_ROW_72_621 VGND VPWR sky130_fd_sc_hd__tapvpwrvgnd_1
XTAP_TAPCELL_ROW_29_364 VGND VPWR sky130_fd_sc_hd__tapvpwrvgnd_1
XTAP_TAPCELL_ROW_12_264 VGND VPWR sky130_fd_sc_hd__tapvpwrvgnd_1
X_5120_ _2549_ VGND VGND VPWR VPWR _0205_ sky130_fd_sc_hd__clkbuf_1
X_5051_ _2401_ reg_file.memory\[6\]\[0\] _2512_ VGND VGND VPWR VPWR _2513_ sky130_fd_sc_hd__mux2_1
X_3381_ _1038_ _1045_ VGND VGND VPWR VPWR _1046_ sky130_fd_sc_hd__nand2_1
X_3450_ _1114_ reg_file.memory\[10\]\[3\] _0645_ VGND VGND VPWR VPWR _1115_ sky130_fd_sc_hd__mux2_1
X_4002_ _0018_ _1637_ VGND VGND VPWR VPWR _1650_ sky130_fd_sc_hd__and2_1
XFILLER_0_62_85 VGND VGND VPWR VPWR sky130_fd_sc_hd__fill_2
X_4904_ alu.ALUResult\[7\] VGND VGND VPWR VPWR _2423_ sky130_fd_sc_hd__buf_1
X_5884_ clknet_leaf_24_clk _0119_ VGND VGND VPWR VPWR reg_file.memory\[4\]\[10\] sky130_fd_sc_hd__dfxtp_1
X_4766_ _2345_ VGND VGND VPWR VPWR _0055_ sky130_fd_sc_hd__clkbuf_1
X_4835_ _2381_ VGND VGND VPWR VPWR _0088_ sky130_fd_sc_hd__clkbuf_1
X_5953_ clknet_leaf_20_clk _0188_ VGND VGND VPWR VPWR reg_file.memory\[6\]\[15\] sky130_fd_sc_hd__dfxtp_1
X_4697_ clk_div.counter\[0\] _2302_ VGND VGND VPWR VPWR _2303_ sky130_fd_sc_hd__and2b_1
X_3579_ _0627_ _0672_ _1243_ VGND VGND VPWR VPWR _1244_ sky130_fd_sc_hd__a21o_1
X_3648_ _1223_ VGND VGND VPWR VPWR _1313_ sky130_fd_sc_hd__inv_2
X_3717_ alu.ALUResult\[27\] seven_seg_conv.temp\[27\] _1351_ VGND VGND VPWR VPWR _1373_
+ sky130_fd_sc_hd__mux2_1
XFILLER_0_30_114 VGND VGND VPWR VPWR sky130_fd_sc_hd__fill_1
X_5249_ reg_file.memory\[8\]\[29\] alu.ALUResult\[29\] _2608_ VGND VGND VPWR VPWR
+ _2618_ sky130_fd_sc_hd__mux2_1
X_5318_ _2652_ VGND VGND VPWR VPWR _0300_ sky130_fd_sc_hd__clkbuf_1
XTAP_TAPCELL_ROW_3_210 VGND VPWR sky130_fd_sc_hd__tapvpwrvgnd_1
XTAP_TAPCELL_ROW_26_345 VGND VPWR sky130_fd_sc_hd__tapvpwrvgnd_1
XPHY_EDGE_ROW_7_Left_98 VGND VGND VPWR VPWR sky130_fd_sc_hd__decap_3
XFILLER_0_21_169 VGND VGND VPWR VPWR sky130_fd_sc_hd__fill_1
XFILLER_0_88_114 VGND VGND VPWR VPWR sky130_fd_sc_hd__fill_1
X_2881_ _0545_ VGND VGND VPWR VPWR _0546_ sky130_fd_sc_hd__buf_4
X_2950_ _0614_ VGND VGND VPWR VPWR _0615_ sky130_fd_sc_hd__buf_2
X_4620_ _0729_ _0737_ _2230_ VGND VGND VPWR VPWR _2239_ sky130_fd_sc_hd__a21o_1
XFILLER_0_44_217 VGND VGND VPWR VPWR sky130_fd_sc_hd__decap_4
XFILLER_0_32_77 VGND VGND VPWR VPWR sky130_fd_sc_hd__fill_1
X_4482_ _1738_ _1845_ _1915_ VGND VGND VPWR VPWR _2113_ sky130_fd_sc_hd__and3_1
X_4551_ _1805_ _1808_ VGND VGND VPWR VPWR _2176_ sky130_fd_sc_hd__nand2_1
X_6221_ clknet_leaf_14_clk _0456_ VGND VGND VPWR VPWR reg_file.memory\[25\]\[27\]
+ sky130_fd_sc_hd__dfxtp_1
XFILLER_0_52_294 VGND VGND VPWR VPWR sky130_fd_sc_hd__fill_1
X_3502_ reg_file.memory\[5\]\[0\] _1166_ _0644_ VGND VGND VPWR VPWR _1167_ sky130_fd_sc_hd__mux2_1
X_3433_ reg_file.memory\[25\]\[4\] _1097_ _0668_ VGND VGND VPWR VPWR _1098_ sky130_fd_sc_hd__mux2_2
XFILLER_0_4_358 VGND VGND VPWR VPWR sky130_fd_sc_hd__decap_6
X_5034_ _2461_ reg_file.memory\[5\]\[25\] _2497_ VGND VGND VPWR VPWR _2503_ sky130_fd_sc_hd__mux2_1
X_5103_ _2461_ reg_file.memory\[6\]\[25\] _2534_ VGND VGND VPWR VPWR _2540_ sky130_fd_sc_hd__mux2_1
X_6152_ clknet_leaf_12_clk _0387_ VGND VGND VPWR VPWR reg_file.memory\[1\]\[22\] sky130_fd_sc_hd__dfxtp_1
X_3364_ reg_file.memory\[25\]\[8\] _1028_ _0669_ VGND VGND VPWR VPWR _1029_ sky130_fd_sc_hd__mux2_1
X_3295_ reg_file.memory\[6\]\[12\] reg_file.memory\[7\]\[12\] _0637_ VGND VGND VPWR
+ VPWR _0960_ sky130_fd_sc_hd__mux2_1
X_6083_ clknet_leaf_19_clk _0318_ VGND VGND VPWR VPWR reg_file.memory\[10\]\[17\]
+ sky130_fd_sc_hd__dfxtp_1
XFILLER_0_79_169 VPWR VGND VPWR VGND sky130_ef_sc_hd__decap_12
XFILLER_0_79_125 VPWR VGND VPWR VGND sky130_ef_sc_hd__decap_12
X_5936_ clknet_leaf_11_clk _0171_ VGND VGND VPWR VPWR reg_file.memory\[5\]\[30\] sky130_fd_sc_hd__dfxtp_1
XTAP_TAPCELL_ROW_48_481 VGND VPWR sky130_fd_sc_hd__tapvpwrvgnd_1
X_5798_ _0531_ _0014_ VGND VGND VPWR VPWR alu.ALUResult\[4\] sky130_fd_sc_hd__dlxtn_1
X_5867_ clk_div.slow_clk _0017_ VGND VGND VPWR VPWR seven_seg_conv.current_digit\[1\]
+ sky130_fd_sc_hd__dfxtp_1
X_4749_ _2335_ VGND VGND VPWR VPWR _0048_ sky130_fd_sc_hd__clkbuf_1
XFILLER_0_7_141 VGND VGND VPWR VPWR sky130_fd_sc_hd__fill_2
XFILLER_0_7_163 VGND VGND VPWR VPWR sky130_fd_sc_hd__decap_4
X_4818_ reg_file.memory\[9\]\[4\] VGND VGND VPWR VPWR _2373_ sky130_fd_sc_hd__clkbuf_1
XTAP_TAPCELL_ROW_23_326 VGND VPWR sky130_fd_sc_hd__tapvpwrvgnd_1
XFILLER_0_43_272 VGND VGND VPWR VPWR sky130_fd_sc_hd__fill_2
Xoutput14 net14 VGND VGND VPWR VPWR cx[4] sky130_fd_sc_hd__buf_1
XFILLER_0_78_29 VGND VGND VPWR VPWR sky130_fd_sc_hd__fill_2
XFILLER_0_34_250 VGND VGND VPWR VPWR sky130_fd_sc_hd__fill_2
X_3080_ reg_file.memory\[15\]\[25\] _0554_ _0618_ _0744_ VGND VGND VPWR VPWR _0745_
+ sky130_fd_sc_hd__a211o_1
XFILLER_0_27_44 VGND VGND VPWR VPWR sky130_fd_sc_hd__fill_1
XTAP_TAPCELL_ROW_45_462 VGND VPWR sky130_fd_sc_hd__tapvpwrvgnd_1
XFILLER_0_43_32 VGND VGND VPWR VPWR sky130_fd_sc_hd__fill_1
X_3982_ _1349_ VGND VGND VPWR VPWR _1635_ sky130_fd_sc_hd__clkbuf_4
XFILLER_0_84_194 VGND VGND VPWR VPWR sky130_fd_sc_hd__fill_2
X_5652_ _2469_ reg_file.memory\[25\]\[29\] _2819_ VGND VGND VPWR VPWR _2829_ sky130_fd_sc_hd__mux2_1
X_5583_ _2469_ reg_file.memory\[21\]\[29\] _2782_ VGND VGND VPWR VPWR _2792_ sky130_fd_sc_hd__mux2_1
X_4603_ _1779_ _2222_ _2223_ VGND VGND VPWR VPWR _2224_ sky130_fd_sc_hd__a21o_1
XFILLER_0_57_331 VGND VGND VPWR VPWR sky130_fd_sc_hd__fill_1
X_2933_ _0597_ VGND VGND VPWR VPWR _0598_ sky130_fd_sc_hd__buf_2
X_5721_ _2863_ VGND VGND VPWR VPWR _0492_ sky130_fd_sc_hd__clkbuf_1
X_4465_ _2093_ _2096_ _0935_ VGND VGND VPWR VPWR _2097_ sky130_fd_sc_hd__o21a_1
X_3416_ _1072_ _1079_ VGND VGND VPWR VPWR _1081_ sky130_fd_sc_hd__and2_1
X_4396_ _2030_ _1197_ _2016_ _2032_ VGND VGND VPWR VPWR _2033_ sky130_fd_sc_hd__o31a_1
X_4534_ _1310_ _2059_ VGND VGND VPWR VPWR _2161_ sky130_fd_sc_hd__nor2_1
XFILLER_0_40_253 VGND VGND VPWR VPWR sky130_fd_sc_hd__fill_2
X_6204_ clknet_leaf_23_clk _0439_ VGND VGND VPWR VPWR reg_file.memory\[25\]\[10\]
+ sky130_fd_sc_hd__dfxtp_1
XFILLER_0_7_21 VGND VGND VPWR VPWR sky130_fd_sc_hd__fill_1
XFILLER_0_7_54 VGND VGND VPWR VPWR sky130_fd_sc_hd__fill_2
XFILLER_0_84_83 VGND VGND VPWR VPWR sky130_fd_sc_hd__fill_1
XTAP_TAPCELL_ROW_68_598 VGND VPWR sky130_fd_sc_hd__tapvpwrvgnd_1
X_3278_ reg_file.memory\[21\]\[13\] _0544_ _0625_ _0942_ VGND VGND VPWR VPWR _0943_
+ sky130_fd_sc_hd__o211ai_2
X_6135_ clknet_leaf_0_clk _0370_ VGND VGND VPWR VPWR reg_file.memory\[1\]\[5\] sky130_fd_sc_hd__dfxtp_1
X_5017_ _2444_ reg_file.memory\[5\]\[17\] _2486_ VGND VGND VPWR VPWR _2494_ sky130_fd_sc_hd__mux2_1
X_3347_ _1009_ _1011_ _0663_ VGND VGND VPWR VPWR _1012_ sky130_fd_sc_hd__mux2_1
X_6066_ clknet_leaf_27_clk _0301_ VGND VGND VPWR VPWR reg_file.memory\[10\]\[0\] sky130_fd_sc_hd__dfxtp_1
XFILLER_0_48_320 VGND VGND VPWR VPWR sky130_fd_sc_hd__fill_1
X_5919_ clknet_leaf_21_clk _0154_ VGND VGND VPWR VPWR reg_file.memory\[5\]\[13\] sky130_fd_sc_hd__dfxtp_1
XFILLER_0_90_197 VGND VGND VPWR VPWR sky130_fd_sc_hd__decap_8
XFILLER_0_90_153 VGND VGND VPWR VPWR sky130_fd_sc_hd__decap_6
XTAP_TAPCELL_ROW_51_498 VGND VPWR sky130_fd_sc_hd__tapvpwrvgnd_1
XFILLER_0_7_3 VPWR VGND VPWR VGND sky130_ef_sc_hd__decap_12
XTAP_TAPCELL_ROW_59_543 VGND VPWR sky130_fd_sc_hd__tapvpwrvgnd_1
XPHY_EDGE_ROW_88_Left_179 VGND VGND VPWR VPWR sky130_fd_sc_hd__decap_3
XTAP_TAPCELL_ROW_42_443 VGND VPWR sky130_fd_sc_hd__tapvpwrvgnd_1
XFILLER_0_13_57 VGND VGND VPWR VPWR sky130_fd_sc_hd__decap_3
X_4250_ _1893_ VGND VGND VPWR VPWR _1894_ sky130_fd_sc_hd__inv_2
XFILLER_0_1_169 VGND VGND VPWR VPWR sky130_fd_sc_hd__fill_1
XFILLER_0_22_297 VGND VGND VPWR VPWR sky130_fd_sc_hd__fill_1
X_4181_ _1824_ _1825_ VGND VGND VPWR VPWR _1826_ sky130_fd_sc_hd__nand2_1
X_3132_ reg_file.memory\[15\]\[22\] _0554_ _0618_ _0796_ VGND VGND VPWR VPWR _0797_
+ sky130_fd_sc_hd__a211o_1
X_3063_ reg_file.memory\[15\]\[26\] _0553_ _0617_ VGND VGND VPWR VPWR _0728_ sky130_fd_sc_hd__a21o_1
X_3201_ reg_file.memory\[8\]\[18\] reg_file.memory\[9\]\[18\] _0639_ VGND VGND VPWR
+ VPWR _0866_ sky130_fd_sc_hd__mux2_1
XFILLER_0_89_264 VGND VGND VPWR VPWR sky130_fd_sc_hd__fill_1
XFILLER_0_70_41 VGND VGND VPWR VPWR sky130_fd_sc_hd__fill_1
XTAP_TAPCELL_ROW_65_579 VGND VPWR sky130_fd_sc_hd__tapvpwrvgnd_1
X_3965_ _1614_ _1618_ _1620_ VGND VGND VPWR VPWR _1621_ sky130_fd_sc_hd__a21o_1
X_5704_ reg_file.memory\[2\]\[23\] VGND VGND VPWR VPWR _2855_ sky130_fd_sc_hd__clkbuf_1
XFILLER_0_72_186 VGND VGND VPWR VPWR sky130_fd_sc_hd__fill_1
XFILLER_0_70_85 VGND VGND VPWR VPWR sky130_fd_sc_hd__fill_1
XFILLER_0_60_326 VGND VGND VPWR VPWR sky130_fd_sc_hd__fill_2
X_2916_ _0580_ VGND VGND VPWR VPWR _0581_ sky130_fd_sc_hd__clkbuf_4
X_5566_ _2783_ VGND VGND VPWR VPWR _0417_ sky130_fd_sc_hd__clkbuf_1
X_5635_ _2820_ VGND VGND VPWR VPWR _0449_ sky130_fd_sc_hd__clkbuf_1
X_3896_ seven_seg_conv.temp\[8\] alu.ALUResult\[8\] _1347_ VGND VGND VPWR VPWR _1552_
+ sky130_fd_sc_hd__mux2_1
X_4379_ _1902_ _2016_ VGND VGND VPWR VPWR _2017_ sky130_fd_sc_hd__nor2_1
X_4517_ _1797_ _2140_ _2141_ _2145_ VGND VGND VPWR VPWR _0513_ sky130_fd_sc_hd__a211o_1
X_4448_ _2080_ _1205_ _2057_ VGND VGND VPWR VPWR _2082_ sky130_fd_sc_hd__or3_1
X_5497_ _2746_ VGND VGND VPWR VPWR _0385_ sky130_fd_sc_hd__clkbuf_1
XTAP_TAPCELL_ROW_56_524 VGND VPWR sky130_fd_sc_hd__tapvpwrvgnd_1
X_6118_ clknet_leaf_15_clk _0353_ VGND VGND VPWR VPWR reg_file.memory\[15\]\[20\]
+ sky130_fd_sc_hd__dfxtp_1
X_6049_ clknet_leaf_20_clk _0284_ VGND VGND VPWR VPWR reg_file.memory\[0\]\[15\] sky130_fd_sc_hd__dfxtp_1
XFILLER_0_48_161 VGND VGND VPWR VPWR sky130_fd_sc_hd__fill_1
X_3681_ ctrl_unit.PCWrite _1328_ _1338_ _1339_ VGND VGND VPWR VPWR _0010_ sky130_fd_sc_hd__a22o_1
XFILLER_0_54_197 VGND VGND VPWR VPWR sky130_fd_sc_hd__decap_3
X_3750_ _1405_ _1399_ _1401_ VGND VGND VPWR VPWR _1406_ sky130_fd_sc_hd__o21ai_1
X_5420_ _2707_ VGND VGND VPWR VPWR _0347_ sky130_fd_sc_hd__clkbuf_1
X_4302_ _1940_ _1943_ VGND VGND VPWR VPWR _1944_ sky130_fd_sc_hd__nor2_1
X_4233_ _1877_ VGND VGND VPWR VPWR _0516_ sky130_fd_sc_hd__clkbuf_1
XFILLER_0_49_75 VGND VGND VPWR VPWR sky130_fd_sc_hd__fill_1
XFILLER_0_4_11 VGND VGND VPWR VPWR sky130_fd_sc_hd__fill_2
X_5351_ _2670_ VGND VGND VPWR VPWR _0315_ sky130_fd_sc_hd__clkbuf_1
X_5282_ _2634_ VGND VGND VPWR VPWR _0282_ sky130_fd_sc_hd__clkbuf_1
XTAP_TAPCELL_ROW_78_660 VGND VPWR sky130_fd_sc_hd__tapvpwrvgnd_1
X_3115_ _0775_ _0779_ _0612_ VGND VGND VPWR VPWR _0780_ sky130_fd_sc_hd__o21a_1
X_4164_ _1682_ _1690_ VGND VGND VPWR VPWR _1809_ sky130_fd_sc_hd__nand2_1
X_4095_ alu.ALUControl\[1\] alu.ALUControl\[0\] alu.ALUControl\[2\] VGND VGND VPWR
+ VPWR _1741_ sky130_fd_sc_hd__or3b_2
X_3046_ _0574_ _0708_ _0710_ _0607_ VGND VGND VPWR VPWR _0711_ sky130_fd_sc_hd__o211a_1
XFILLER_0_4_88 VGND VGND VPWR VPWR sky130_fd_sc_hd__fill_1
X_4997_ _2483_ VGND VGND VPWR VPWR _0148_ sky130_fd_sc_hd__clkbuf_1
X_3948_ _1602_ _1598_ _1603_ VGND VGND VPWR VPWR _1604_ sky130_fd_sc_hd__mux2_1
XFILLER_0_60_178 VGND VGND VPWR VPWR sky130_fd_sc_hd__fill_2
X_5549_ _2774_ VGND VGND VPWR VPWR _0409_ sky130_fd_sc_hd__clkbuf_1
X_5618_ _2811_ VGND VGND VPWR VPWR _0441_ sky130_fd_sc_hd__clkbuf_1
X_3879_ _1515_ _1523_ VGND VGND VPWR VPWR _1535_ sky130_fd_sc_hd__xor2_1
XTAP_TAPCELL_ROW_84_696 VGND VPWR sky130_fd_sc_hd__tapvpwrvgnd_1
XFILLER_0_68_289 VGND VGND VPWR VPWR sky130_fd_sc_hd__fill_1
XFILLER_0_68_234 VGND VGND VPWR VPWR sky130_fd_sc_hd__fill_1
XFILLER_0_83_237 VGND VGND VPWR VPWR sky130_fd_sc_hd__fill_2
XFILLER_0_36_197 VPWR VGND VPWR VGND sky130_ef_sc_hd__decap_12
XFILLER_0_36_131 VGND VGND VPWR VPWR sky130_fd_sc_hd__decap_8
XFILLER_0_36_120 VGND VGND VPWR VPWR sky130_fd_sc_hd__fill_2
XFILLER_0_24_326 VGND VGND VPWR VPWR sky130_fd_sc_hd__fill_2
XTAP_TAPCELL_ROW_75_641 VGND VPWR sky130_fd_sc_hd__tapvpwrvgnd_1
XFILLER_0_35_55 VGND VGND VPWR VPWR sky130_fd_sc_hd__fill_1
XFILLER_0_59_223 VGND VGND VPWR VPWR sky130_fd_sc_hd__fill_1
X_4920_ alu.ALUResult\[12\] VGND VGND VPWR VPWR _2434_ sky130_fd_sc_hd__buf_1
XFILLER_0_27_142 VGND VGND VPWR VPWR sky130_fd_sc_hd__fill_1
X_3802_ _1453_ _1454_ VGND VGND VPWR VPWR _1458_ sky130_fd_sc_hd__and2_1
X_4782_ _2340_ seven_seg_conv.temp\[15\] _2354_ VGND VGND VPWR VPWR _0062_ sky130_fd_sc_hd__a21bo_1
X_4851_ _2389_ VGND VGND VPWR VPWR _0096_ sky130_fd_sc_hd__clkbuf_1
X_3664_ _0547_ _0555_ _0548_ _0550_ VGND VGND VPWR VPWR _1327_ sky130_fd_sc_hd__a211o_1
X_3595_ _1252_ _1259_ VGND VGND VPWR VPWR _1260_ sky130_fd_sc_hd__xnor2_1
X_3733_ _1376_ alu.ALUResult\[29\] alu.ALUResult\[31\] _1345_ VGND VGND VPWR VPWR
+ _1389_ sky130_fd_sc_hd__and4bb_1
X_5403_ _2698_ VGND VGND VPWR VPWR _0339_ sky130_fd_sc_hd__clkbuf_1
XFILLER_0_30_318 VGND VGND VPWR VPWR sky130_fd_sc_hd__fill_1
X_4216_ _1856_ _1860_ _1686_ VGND VGND VPWR VPWR _1861_ sky130_fd_sc_hd__mux2_1
X_4147_ _1738_ _1740_ _1742_ _1744_ _1792_ VGND VGND VPWR VPWR _1793_ sky130_fd_sc_hd__a311o_1
XFILLER_0_48_3 VGND VGND VPWR VPWR sky130_fd_sc_hd__decap_3
X_5265_ reg_file.memory\[0\]\[5\] VGND VGND VPWR VPWR _2626_ sky130_fd_sc_hd__clkbuf_1
X_5196_ _2590_ VGND VGND VPWR VPWR _0240_ sky130_fd_sc_hd__clkbuf_1
X_5334_ _2661_ VGND VGND VPWR VPWR _0307_ sky130_fd_sc_hd__clkbuf_1
X_3029_ _0600_ _0693_ VGND VGND VPWR VPWR _0694_ sky130_fd_sc_hd__or2_1
X_4078_ _1710_ _1723_ VGND VGND VPWR VPWR _1724_ sky130_fd_sc_hd__nand2_1
XTAP_TAPCELL_ROW_81_677 VGND VPWR sky130_fd_sc_hd__tapvpwrvgnd_1
XFILLER_0_65_259 VGND VGND VPWR VPWR sky130_fd_sc_hd__fill_2
Xclkload2 clknet_leaf_2_clk VGND VGND VPWR VPWR clkload2/Y sky130_fd_sc_hd__inv_8
XFILLER_0_33_134 VGND VGND VPWR VPWR sky130_fd_sc_hd__fill_2
XTAP_TAPCELL_ROW_89_722 VGND VPWR sky130_fd_sc_hd__tapvpwrvgnd_1
XTAP_TAPCELL_ROW_72_622 VGND VPWR sky130_fd_sc_hd__tapvpwrvgnd_1
XTAP_TAPCELL_ROW_29_365 VGND VPWR sky130_fd_sc_hd__tapvpwrvgnd_1
XFILLER_0_71_218 VGND VGND VPWR VPWR sky130_fd_sc_hd__decap_6
XFILLER_0_12_307 VGND VGND VPWR VPWR sky130_fd_sc_hd__fill_1
XTAP_TAPCELL_ROW_12_265 VGND VPWR sky130_fd_sc_hd__tapvpwrvgnd_1
X_3380_ reg_file.memory\[25\]\[7\] _1044_ _0669_ VGND VGND VPWR VPWR _1045_ sky130_fd_sc_hd__mux2_1
X_5050_ _2511_ VGND VGND VPWR VPWR _2512_ sky130_fd_sc_hd__clkbuf_4
X_4001_ _0017_ _1643_ _1648_ _1649_ VGND VGND VPWR VPWR _0004_ sky130_fd_sc_hd__a31o_1
X_5952_ clknet_leaf_20_clk _0187_ VGND VGND VPWR VPWR reg_file.memory\[6\]\[14\] sky130_fd_sc_hd__dfxtp_1
X_4903_ _2422_ VGND VGND VPWR VPWR _0115_ sky130_fd_sc_hd__clkbuf_1
X_3716_ alu.ALUResult\[25\] seven_seg_conv.temp\[25\] _1351_ VGND VGND VPWR VPWR _1372_
+ sky130_fd_sc_hd__mux2_1
X_5883_ clknet_leaf_24_clk _0118_ VGND VGND VPWR VPWR reg_file.memory\[4\]\[9\] sky130_fd_sc_hd__dfxtp_1
X_4765_ seven_seg_conv.temp\[8\] _1550_ _2334_ VGND VGND VPWR VPWR _2345_ sky130_fd_sc_hd__mux2_1
X_4834_ reg_file.memory\[9\]\[12\] VGND VGND VPWR VPWR _2381_ sky130_fd_sc_hd__clkbuf_1
X_4696_ _2298_ _2299_ _2300_ _2301_ VGND VGND VPWR VPWR _2302_ sky130_fd_sc_hd__or4_4
X_3578_ _0690_ _1241_ _1242_ VGND VGND VPWR VPWR _1243_ sky130_fd_sc_hd__a21oi_1
X_5317_ reg_file.memory\[0\]\[31\] VGND VGND VPWR VPWR _2652_ sky130_fd_sc_hd__clkbuf_1
X_3647_ _0838_ _1221_ VGND VGND VPWR VPWR _1312_ sky130_fd_sc_hd__xor2_1
X_5248_ _2617_ VGND VGND VPWR VPWR _0265_ sky130_fd_sc_hd__clkbuf_1
X_5179_ _2469_ reg_file.memory\[7\]\[29\] _2570_ VGND VGND VPWR VPWR _2580_ sky130_fd_sc_hd__mux2_1
XTAP_TAPCELL_ROW_3_211 VGND VPWR sky130_fd_sc_hd__tapvpwrvgnd_1
XTAP_TAPCELL_ROW_26_346 VGND VPWR sky130_fd_sc_hd__tapvpwrvgnd_1
XFILLER_0_88_137 VGND VGND VPWR VPWR sky130_fd_sc_hd__decap_3
X_2880_ _0544_ VGND VGND VPWR VPWR _0545_ sky130_fd_sc_hd__clkbuf_8
XFILLER_0_52_251 VGND VGND VPWR VPWR sky130_fd_sc_hd__fill_1
X_6220_ clknet_leaf_14_clk _0455_ VGND VGND VPWR VPWR reg_file.memory\[25\]\[26\]
+ sky130_fd_sc_hd__dfxtp_1
X_3501_ reg_file.memory\[6\]\[0\] reg_file.memory\[7\]\[0\] _0635_ VGND VGND VPWR
+ VPWR _1166_ sky130_fd_sc_hd__mux2_1
X_4550_ _2168_ _2169_ _2175_ VGND VGND VPWR VPWR _0517_ sky130_fd_sc_hd__o21ai_1
X_4481_ _2110_ _2111_ _1999_ VGND VGND VPWR VPWR _2112_ sky130_fd_sc_hd__and3b_1
X_6151_ clknet_leaf_16_clk _0386_ VGND VGND VPWR VPWR reg_file.memory\[1\]\[21\] sky130_fd_sc_hd__dfxtp_1
X_3432_ _1094_ _1096_ _0662_ VGND VGND VPWR VPWR _1097_ sky130_fd_sc_hd__mux2_1
XFILLER_0_12_104 VGND VGND VPWR VPWR sky130_fd_sc_hd__fill_2
X_3363_ _1025_ _1027_ _0663_ VGND VGND VPWR VPWR _1028_ sky130_fd_sc_hd__mux2_1
X_5102_ _2539_ VGND VGND VPWR VPWR _0197_ sky130_fd_sc_hd__clkbuf_1
X_5033_ _2502_ VGND VGND VPWR VPWR _0165_ sky130_fd_sc_hd__clkbuf_1
X_3294_ reg_file.memory\[21\]\[12\] _0544_ _0624_ _0958_ VGND VGND VPWR VPWR _0959_
+ sky130_fd_sc_hd__o211ai_2
X_6082_ clknet_leaf_20_clk _0317_ VGND VGND VPWR VPWR reg_file.memory\[10\]\[16\]
+ sky130_fd_sc_hd__dfxtp_1
X_5935_ clknet_leaf_10_clk _0170_ VGND VGND VPWR VPWR reg_file.memory\[5\]\[29\] sky130_fd_sc_hd__dfxtp_1
XFILLER_0_79_137 VPWR VGND VPWR VGND sky130_ef_sc_hd__decap_12
X_5866_ clk_div.slow_clk _0016_ VGND VGND VPWR VPWR seven_seg_conv.current_digit\[0\]
+ sky130_fd_sc_hd__dfxtp_1
XTAP_TAPCELL_ROW_23_327 VGND VPWR sky130_fd_sc_hd__tapvpwrvgnd_1
XFILLER_0_90_335 VGND VGND VPWR VPWR sky130_fd_sc_hd__fill_1
X_4679_ seven_seg_conv.digit_counter\[0\] _2292_ VGND VGND VPWR VPWR _2293_ sky130_fd_sc_hd__nand2_1
X_5797_ _0530_ _0014_ VGND VGND VPWR VPWR alu.ALUResult\[3\] sky130_fd_sc_hd__dlxtn_1
X_4748_ seven_seg_conv.temp\[1\] _1616_ _2334_ VGND VGND VPWR VPWR _2335_ sky130_fd_sc_hd__mux2_1
XFILLER_0_7_186 VGND VGND VPWR VPWR sky130_fd_sc_hd__fill_1
X_4817_ _2372_ VGND VGND VPWR VPWR _0079_ sky130_fd_sc_hd__clkbuf_1
XPHY_EDGE_ROW_1_Right_1 VGND VGND VPWR VPWR sky130_fd_sc_hd__decap_3
Xoutput15 net15 VGND VGND VPWR VPWR cx[5] sky130_fd_sc_hd__buf_1
XFILLER_0_85_129 VPWR VGND VPWR VGND sky130_ef_sc_hd__decap_12
XFILLER_0_81_335 VGND VGND VPWR VPWR sky130_fd_sc_hd__fill_1
XFILLER_0_26_229 VGND VGND VPWR VPWR sky130_fd_sc_hd__fill_1
XFILLER_0_19_270 VGND VGND VPWR VPWR sky130_fd_sc_hd__fill_2
X_2932_ _0569_ _0565_ VGND VGND VPWR VPWR _0597_ sky130_fd_sc_hd__and2_2
X_5720_ reg_file.memory\[2\]\[31\] VGND VGND VPWR VPWR _2863_ sky130_fd_sc_hd__clkbuf_1
XTAP_TAPCELL_ROW_45_463 VGND VPWR sky130_fd_sc_hd__tapvpwrvgnd_1
X_3981_ _0016_ _0017_ VGND VGND VPWR VPWR _1634_ sky130_fd_sc_hd__nor2_1
X_5651_ _2828_ VGND VGND VPWR VPWR _0457_ sky130_fd_sc_hd__clkbuf_1
X_5582_ _2791_ VGND VGND VPWR VPWR _0425_ sky130_fd_sc_hd__clkbuf_1
X_4602_ _1779_ _2200_ VGND VGND VPWR VPWR _2223_ sky130_fd_sc_hd__nor2_1
X_4533_ _1920_ _2159_ _1976_ _1928_ VGND VGND VPWR VPWR _2160_ sky130_fd_sc_hd__o2bb2a_1
XTAP_TAPCELL_ROW_20_308 VGND VPWR sky130_fd_sc_hd__tapvpwrvgnd_1
XFILLER_0_68_85 VPWR VGND VPWR VGND sky130_ef_sc_hd__decap_12
X_3415_ _1072_ _1079_ VGND VGND VPWR VPWR _1080_ sky130_fd_sc_hd__nor2_1
X_4464_ _0943_ _0950_ VGND VGND VPWR VPWR _2096_ sky130_fd_sc_hd__and2b_1
X_4395_ _1902_ _2031_ VGND VGND VPWR VPWR _2032_ sky130_fd_sc_hd__nor2_1
X_6203_ clknet_leaf_23_clk _0438_ VGND VGND VPWR VPWR reg_file.memory\[25\]\[9\] sky130_fd_sc_hd__dfxtp_1
X_6134_ clknet_leaf_0_clk _0369_ VGND VGND VPWR VPWR reg_file.memory\[1\]\[4\] sky130_fd_sc_hd__dfxtp_1
X_3346_ _1010_ reg_file.memory\[10\]\[9\] _0646_ VGND VGND VPWR VPWR _1011_ sky130_fd_sc_hd__mux2_1
XTAP_TAPCELL_ROW_68_599 VGND VPWR sky130_fd_sc_hd__tapvpwrvgnd_1
X_6065_ clknet_leaf_11_clk _0300_ VGND VGND VPWR VPWR reg_file.memory\[0\]\[31\] sky130_fd_sc_hd__dfxtp_1
X_3277_ reg_file.memory\[15\]\[13\] _0553_ _0617_ _0941_ VGND VGND VPWR VPWR _0942_
+ sky130_fd_sc_hd__a211o_1
X_5016_ _2493_ VGND VGND VPWR VPWR _0157_ sky130_fd_sc_hd__clkbuf_1
X_5849_ clknet_leaf_10_clk _0099_ VGND VGND VPWR VPWR reg_file.memory\[9\]\[23\] sky130_fd_sc_hd__dfxtp_1
XFILLER_0_75_151 VGND VGND VPWR VPWR sky130_fd_sc_hd__decap_4
XFILLER_0_63_335 VGND VGND VPWR VPWR sky130_fd_sc_hd__fill_1
X_5918_ clknet_leaf_21_clk _0153_ VGND VGND VPWR VPWR reg_file.memory\[5\]\[12\] sky130_fd_sc_hd__dfxtp_1
XTAP_TAPCELL_ROW_51_499 VGND VPWR sky130_fd_sc_hd__tapvpwrvgnd_1
XTAP_TAPCELL_ROW_59_544 VGND VPWR sky130_fd_sc_hd__tapvpwrvgnd_1
XFILLER_0_66_184 VGND VGND VPWR VPWR sky130_fd_sc_hd__decap_3
XTAP_TAPCELL_ROW_42_444 VGND VPWR sky130_fd_sc_hd__tapvpwrvgnd_1
Xclkbuf_leaf_24_clk clknet_1_0__leaf_clk VGND VGND VPWR VPWR clknet_leaf_24_clk sky130_fd_sc_hd__clkbuf_8
X_4180_ _1659_ _1714_ VGND VGND VPWR VPWR _1825_ sky130_fd_sc_hd__or2_1
X_3200_ reg_file.memory\[0\]\[18\] _0864_ _0655_ VGND VGND VPWR VPWR _0865_ sky130_fd_sc_hd__mux2_1
XFILLER_0_54_43 VGND VGND VPWR VPWR sky130_fd_sc_hd__fill_2
XFILLER_0_54_32 VGND VGND VPWR VPWR sky130_fd_sc_hd__decap_4
X_3131_ _0791_ _0795_ _0612_ VGND VGND VPWR VPWR _0796_ sky130_fd_sc_hd__o21a_1
X_3062_ _0722_ _0726_ _0611_ VGND VGND VPWR VPWR _0727_ sky130_fd_sc_hd__o21a_1
X_5703_ _2854_ VGND VGND VPWR VPWR _0483_ sky130_fd_sc_hd__clkbuf_1
Xclkbuf_leaf_15_clk clknet_1_0__leaf_clk VGND VGND VPWR VPWR clknet_leaf_15_clk sky130_fd_sc_hd__clkbuf_8
X_2915_ _0579_ VGND VGND VPWR VPWR _0580_ sky130_fd_sc_hd__clkbuf_4
X_3964_ _1612_ _1619_ VGND VGND VPWR VPWR _1620_ sky130_fd_sc_hd__and2_1
X_3895_ _1358_ _1550_ VGND VGND VPWR VPWR _1551_ sky130_fd_sc_hd__xnor2_2
X_4516_ _1215_ _2143_ _2144_ VGND VGND VPWR VPWR _2145_ sky130_fd_sc_hd__a21oi_1
X_5565_ _2450_ reg_file.memory\[21\]\[20\] _2782_ VGND VGND VPWR VPWR _2783_ sky130_fd_sc_hd__mux2_1
X_5634_ _2450_ reg_file.memory\[25\]\[20\] _2819_ VGND VGND VPWR VPWR _2820_ sky130_fd_sc_hd__mux2_1
X_5496_ reg_file.memory\[1\]\[20\] VGND VGND VPWR VPWR _2746_ sky130_fd_sc_hd__clkbuf_1
XFILLER_0_13_254 VGND VGND VPWR VPWR sky130_fd_sc_hd__fill_1
X_4378_ _2015_ _1997_ _1194_ VGND VGND VPWR VPWR _2016_ sky130_fd_sc_hd__o21a_1
X_4447_ _2080_ _2057_ _1205_ VGND VGND VPWR VPWR _2081_ sky130_fd_sc_hd__o21a_1
X_6117_ clknet_leaf_21_clk _0352_ VGND VGND VPWR VPWR reg_file.memory\[15\]\[19\]
+ sky130_fd_sc_hd__dfxtp_1
X_3329_ reg_file.memory\[8\]\[10\] reg_file.memory\[9\]\[10\] _0637_ VGND VGND VPWR
+ VPWR _0994_ sky130_fd_sc_hd__mux2_1
XTAP_TAPCELL_ROW_56_525 VGND VPWR sky130_fd_sc_hd__tapvpwrvgnd_1
X_6048_ clknet_leaf_20_clk _0283_ VGND VGND VPWR VPWR reg_file.memory\[0\]\[14\] sky130_fd_sc_hd__dfxtp_1
XFILLER_0_27_335 VGND VGND VPWR VPWR sky130_fd_sc_hd__fill_1
X_3680_ _0537_ _0542_ VGND VGND VPWR VPWR _1339_ sky130_fd_sc_hd__nand2_1
XFILLER_0_54_187 VGND VGND VPWR VPWR sky130_fd_sc_hd__fill_1
XFILLER_0_54_165 VGND VGND VPWR VPWR sky130_fd_sc_hd__decap_3
XFILLER_0_40_89 VGND VGND VPWR VPWR sky130_fd_sc_hd__fill_2
X_5350_ reg_file.memory\[10\]\[14\] alu.ALUResult\[14\] _2665_ VGND VGND VPWR VPWR
+ _2670_ sky130_fd_sc_hd__mux2_1
X_4163_ _1689_ _1683_ VGND VGND VPWR VPWR _1808_ sky130_fd_sc_hd__nand2_1
X_4301_ _1781_ _1942_ _1732_ VGND VGND VPWR VPWR _1943_ sky130_fd_sc_hd__mux2_1
X_4232_ _1871_ _1873_ _1876_ VGND VGND VPWR VPWR _1877_ sky130_fd_sc_hd__or3b_1
Xclkbuf_leaf_4_clk clknet_1_1__leaf_clk VGND VGND VPWR VPWR clknet_leaf_4_clk sky130_fd_sc_hd__clkbuf_8
X_5281_ reg_file.memory\[0\]\[13\] VGND VGND VPWR VPWR _2634_ sky130_fd_sc_hd__clkbuf_1
XFILLER_0_81_30 VGND VGND VPWR VPWR sky130_fd_sc_hd__fill_1
X_3114_ _0575_ _0776_ _0778_ _0607_ VGND VGND VPWR VPWR _0779_ sky130_fd_sc_hd__o211a_1
XTAP_TAPCELL_ROW_78_661 VGND VPWR sky130_fd_sc_hd__tapvpwrvgnd_1
X_4094_ _1154_ _1739_ VGND VGND VPWR VPWR _1740_ sky130_fd_sc_hd__nor2_2
X_3045_ _0600_ _0709_ VGND VGND VPWR VPWR _0710_ sky130_fd_sc_hd__or2_1
XTAP_TAPCELL_ROW_53_506 VGND VPWR sky130_fd_sc_hd__tapvpwrvgnd_1
XFILLER_0_60_102 VGND VGND VPWR VPWR sky130_fd_sc_hd__decap_4
XFILLER_0_45_154 VGND VGND VPWR VPWR sky130_fd_sc_hd__fill_1
X_4996_ _2423_ reg_file.memory\[5\]\[7\] _2475_ VGND VGND VPWR VPWR _2483_ sky130_fd_sc_hd__mux2_1
X_3878_ _1533_ _1525_ VGND VGND VPWR VPWR _1534_ sky130_fd_sc_hd__nor2_1
XFILLER_0_5_240 VGND VGND VPWR VPWR sky130_fd_sc_hd__decap_8
X_3947_ _1594_ _1596_ VGND VGND VPWR VPWR _1603_ sky130_fd_sc_hd__xor2_1
X_5548_ _2434_ reg_file.memory\[21\]\[12\] _2771_ VGND VGND VPWR VPWR _2774_ sky130_fd_sc_hd__mux2_1
X_5617_ _2434_ reg_file.memory\[25\]\[12\] _2808_ VGND VGND VPWR VPWR _2811_ sky130_fd_sc_hd__mux2_1
XFILLER_0_5_273 VGND VGND VPWR VPWR sky130_fd_sc_hd__decap_6
X_5479_ _2737_ VGND VGND VPWR VPWR _0376_ sky130_fd_sc_hd__clkbuf_1
XTAP_TAPCELL_ROW_84_697 VGND VPWR sky130_fd_sc_hd__tapvpwrvgnd_1
XTAP_TAPCELL_ROW_1_194 VGND VPWR sky130_fd_sc_hd__tapvpwrvgnd_1
XFILLER_0_51_157 VGND VGND VPWR VPWR sky130_fd_sc_hd__fill_2
XTAP_TAPCELL_ROW_75_642 VGND VPWR sky130_fd_sc_hd__tapvpwrvgnd_1
XFILLER_0_59_235 VGND VGND VPWR VPWR sky130_fd_sc_hd__decap_3
X_3732_ alu.ALUResult\[28\] _1375_ _1345_ _1376_ _1377_ VGND VGND VPWR VPWR _1388_
+ sky130_fd_sc_hd__o2111a_1
X_3801_ _1367_ _1444_ _1452_ _1456_ _1365_ VGND VGND VPWR VPWR _1457_ sky130_fd_sc_hd__a311o_1
X_4781_ _1487_ _1489_ _1344_ VGND VGND VPWR VPWR _2354_ sky130_fd_sc_hd__a21o_1
X_4850_ reg_file.memory\[9\]\[20\] VGND VGND VPWR VPWR _2389_ sky130_fd_sc_hd__clkbuf_1
Xclkload20 clknet_leaf_7_clk VGND VGND VPWR VPWR clkload20/Y sky130_fd_sc_hd__clkinv_16
X_3663_ _0557_ _0584_ VGND VGND VPWR VPWR _1326_ sky130_fd_sc_hd__and2b_1
X_3594_ reg_file.memory\[25\]\[31\] _1258_ _0671_ VGND VGND VPWR VPWR _1259_ sky130_fd_sc_hd__mux2_1
X_5402_ _2421_ reg_file.memory\[15\]\[6\] _2691_ VGND VGND VPWR VPWR _2698_ sky130_fd_sc_hd__mux2_1
X_5333_ reg_file.memory\[10\]\[6\] alu.ALUResult\[6\] _2654_ VGND VGND VPWR VPWR _2661_
+ sky130_fd_sc_hd__mux2_1
X_4146_ _1708_ _1766_ _1791_ VGND VGND VPWR VPWR _1792_ sky130_fd_sc_hd__o21ai_1
XFILLER_0_76_85 VGND VGND VPWR VPWR sky130_fd_sc_hd__decap_4
X_4215_ _1859_ VGND VGND VPWR VPWR _1860_ sky130_fd_sc_hd__inv_2
X_5264_ _2625_ VGND VGND VPWR VPWR _0273_ sky130_fd_sc_hd__clkbuf_1
X_5195_ reg_file.memory\[8\]\[3\] alu.ALUResult\[3\] _2586_ VGND VGND VPWR VPWR _2590_
+ sky130_fd_sc_hd__mux2_1
XTAP_TAPCELL_ROW_81_678 VGND VPWR sky130_fd_sc_hd__tapvpwrvgnd_1
X_3028_ reg_file.memory\[0\]\[28\] reg_file.memory\[1\]\[28\] _0594_ VGND VGND VPWR
+ VPWR _0693_ sky130_fd_sc_hd__mux2_1
X_4077_ _0737_ _1697_ VGND VGND VPWR VPWR _1723_ sky130_fd_sc_hd__nand2_1
X_4979_ _2473_ VGND VGND VPWR VPWR _0140_ sky130_fd_sc_hd__clkbuf_1
Xclkload3 clknet_leaf_15_clk VGND VGND VPWR VPWR clkload3/Y sky130_fd_sc_hd__inv_8
XTAP_TAPCELL_ROW_89_723 VGND VPWR sky130_fd_sc_hd__tapvpwrvgnd_1
XTAP_TAPCELL_ROW_29_366 VGND VPWR sky130_fd_sc_hd__tapvpwrvgnd_1
XTAP_TAPCELL_ROW_72_623 VGND VPWR sky130_fd_sc_hd__tapvpwrvgnd_1
XFILLER_0_56_238 VGND VGND VPWR VPWR sky130_fd_sc_hd__fill_1
X_4000_ _1636_ _0017_ _0018_ _0019_ VGND VGND VPWR VPWR _1649_ sky130_fd_sc_hd__o211a_1
XFILLER_0_20_363 VGND VGND VPWR VPWR sky130_fd_sc_hd__fill_1
XFILLER_0_47_205 VGND VGND VPWR VPWR sky130_fd_sc_hd__decap_6
X_4902_ _2421_ reg_file.memory\[4\]\[6\] _2409_ VGND VGND VPWR VPWR _2422_ sky130_fd_sc_hd__mux2_1
X_5882_ clknet_leaf_26_clk _0117_ VGND VGND VPWR VPWR reg_file.memory\[4\]\[8\] sky130_fd_sc_hd__dfxtp_1
X_5951_ clknet_leaf_21_clk _0186_ VGND VGND VPWR VPWR reg_file.memory\[6\]\[13\] sky130_fd_sc_hd__dfxtp_1
X_4695_ clk_div.counter\[9\] clk_div.counter\[8\] clk_div.counter\[7\] clk_div.counter\[6\]
+ VGND VGND VPWR VPWR _2301_ sky130_fd_sc_hd__or4bb_1
XFILLER_0_70_263 VGND VGND VPWR VPWR sky130_fd_sc_hd__fill_1
XFILLER_0_70_230 VGND VGND VPWR VPWR sky130_fd_sc_hd__decap_3
X_4833_ _2380_ VGND VGND VPWR VPWR _0087_ sky130_fd_sc_hd__clkbuf_1
X_4764_ _2340_ seven_seg_conv.temp\[7\] _2344_ VGND VGND VPWR VPWR _0054_ sky130_fd_sc_hd__a21bo_1
XFILLER_0_15_113 VGND VGND VPWR VPWR sky130_fd_sc_hd__fill_2
X_3715_ _1370_ VGND VGND VPWR VPWR _1371_ sky130_fd_sc_hd__inv_2
X_5247_ reg_file.memory\[8\]\[28\] alu.ALUResult\[28\] _2608_ VGND VGND VPWR VPWR
+ _2617_ sky130_fd_sc_hd__mux2_1
X_5316_ _2651_ VGND VGND VPWR VPWR _0299_ sky130_fd_sc_hd__clkbuf_1
X_3577_ _0627_ _0672_ VGND VGND VPWR VPWR _1242_ sky130_fd_sc_hd__xnor2_1
X_3646_ _1303_ _1305_ _1307_ _1310_ VGND VGND VPWR VPWR _1311_ sky130_fd_sc_hd__or4bb_1
XTAP_TAPCELL_ROW_86_704 VGND VPWR sky130_fd_sc_hd__tapvpwrvgnd_1
X_4129_ _1679_ _1774_ VGND VGND VPWR VPWR _1775_ sky130_fd_sc_hd__nor2_1
X_5178_ _2579_ VGND VGND VPWR VPWR _0233_ sky130_fd_sc_hd__clkbuf_1
XFILLER_0_38_216 VGND VGND VPWR VPWR sky130_fd_sc_hd__fill_1
XTAP_TAPCELL_ROW_26_347 VGND VPWR sky130_fd_sc_hd__tapvpwrvgnd_1
XFILLER_0_69_363 VGND VGND VPWR VPWR sky130_fd_sc_hd__fill_1
X_3500_ _0590_ _0623_ _1164_ VGND VGND VPWR VPWR _1165_ sky130_fd_sc_hd__o21a_2
XFILLER_0_32_46 VGND VGND VPWR VPWR sky130_fd_sc_hd__decap_3
XFILLER_0_32_24 VGND VGND VPWR VPWR sky130_fd_sc_hd__decap_4
X_5101_ _2459_ reg_file.memory\[6\]\[24\] _2534_ VGND VGND VPWR VPWR _2539_ sky130_fd_sc_hd__mux2_1
X_4480_ _2109_ _1273_ _2097_ VGND VGND VPWR VPWR _2111_ sky130_fd_sc_hd__or3_1
X_6150_ clknet_leaf_17_clk _0385_ VGND VGND VPWR VPWR reg_file.memory\[1\]\[20\] sky130_fd_sc_hd__dfxtp_1
XPHY_EDGE_ROW_29_Left_120 VGND VGND VPWR VPWR sky130_fd_sc_hd__decap_3
XFILLER_0_12_138 VGND VGND VPWR VPWR sky130_fd_sc_hd__fill_2
X_3362_ _1026_ reg_file.memory\[10\]\[8\] _0646_ VGND VGND VPWR VPWR _1027_ sky130_fd_sc_hd__mux2_1
X_3431_ _1095_ reg_file.memory\[10\]\[4\] _0644_ VGND VGND VPWR VPWR _1096_ sky130_fd_sc_hd__mux2_1
XFILLER_0_79_149 VGND VGND VPWR VPWR sky130_fd_sc_hd__decap_4
X_5032_ _2459_ reg_file.memory\[5\]\[24\] _2497_ VGND VGND VPWR VPWR _2502_ sky130_fd_sc_hd__mux2_1
X_3293_ reg_file.memory\[15\]\[12\] _0552_ _0616_ _0957_ VGND VGND VPWR VPWR _0958_
+ sky130_fd_sc_hd__a211o_1
X_6081_ clknet_leaf_19_clk _0316_ VGND VGND VPWR VPWR reg_file.memory\[10\]\[15\]
+ sky130_fd_sc_hd__dfxtp_1
X_5934_ clknet_leaf_9_clk _0169_ VGND VGND VPWR VPWR reg_file.memory\[5\]\[28\] sky130_fd_sc_hd__dfxtp_1
X_5865_ clknet_leaf_6_clk _0108_ VGND VGND VPWR VPWR clk_div.slow_clk sky130_fd_sc_hd__dfxtp_4
X_4816_ reg_file.memory\[9\]\[3\] VGND VGND VPWR VPWR _2372_ sky130_fd_sc_hd__clkbuf_1
XTAP_TAPCELL_ROW_23_328 VGND VPWR sky130_fd_sc_hd__tapvpwrvgnd_1
X_4678_ seven_seg_conv.digit_counter\[1\] VGND VGND VPWR VPWR _2292_ sky130_fd_sc_hd__inv_2
X_3629_ _1177_ _1176_ _1292_ _1293_ VGND VGND VPWR VPWR _1294_ sky130_fd_sc_hd__or4_1
X_5796_ _0527_ _0014_ VGND VGND VPWR VPWR alu.ALUResult\[2\] sky130_fd_sc_hd__dlxtn_1
X_4747_ _1635_ VGND VGND VPWR VPWR _2334_ sky130_fd_sc_hd__buf_4
Xoutput16 net16 VGND VGND VPWR VPWR cx[6] sky130_fd_sc_hd__buf_1
XFILLER_0_84_141 VPWR VGND VPWR VGND sky130_ef_sc_hd__decap_12
X_5650_ _2467_ reg_file.memory\[25\]\[28\] _2819_ VGND VGND VPWR VPWR _2828_ sky130_fd_sc_hd__mux2_1
X_2931_ reg_file.memory\[4\]\[30\] reg_file.memory\[5\]\[30\] _0595_ VGND VGND VPWR
+ VPWR _0596_ sky130_fd_sc_hd__mux2_1
Xclkbuf_0_clk clk VGND VGND VPWR VPWR clknet_0_clk sky130_fd_sc_hd__clkbuf_16
XFILLER_0_43_45 VGND VGND VPWR VPWR sky130_fd_sc_hd__fill_2
X_3980_ _1633_ VGND VGND VPWR VPWR _0019_ sky130_fd_sc_hd__buf_6
X_5581_ _2467_ reg_file.memory\[21\]\[28\] _2782_ VGND VGND VPWR VPWR _2791_ sky130_fd_sc_hd__mux2_1
X_4601_ _1801_ _1818_ VGND VGND VPWR VPWR _2222_ sky130_fd_sc_hd__and2_1
X_4532_ _2071_ _2063_ _2158_ _2064_ _2130_ VGND VGND VPWR VPWR _2159_ sky130_fd_sc_hd__o221a_1
X_4463_ _1797_ _2090_ _2091_ _2095_ VGND VGND VPWR VPWR _0509_ sky130_fd_sc_hd__a211o_1
XFILLER_0_4_157 VGND VGND VPWR VPWR sky130_fd_sc_hd__fill_2
XTAP_TAPCELL_ROW_20_309 VGND VPWR sky130_fd_sc_hd__tapvpwrvgnd_1
X_6064_ clknet_leaf_11_clk _0299_ VGND VGND VPWR VPWR reg_file.memory\[0\]\[30\] sky130_fd_sc_hd__dfxtp_1
XFILLER_0_68_97 VGND VGND VPWR VPWR sky130_fd_sc_hd__decap_3
X_3414_ reg_file.memory\[25\]\[5\] _1078_ _0668_ VGND VGND VPWR VPWR _1079_ sky130_fd_sc_hd__mux2_1
X_4394_ _2030_ _2016_ _1197_ VGND VGND VPWR VPWR _2031_ sky130_fd_sc_hd__o21a_1
XFILLER_0_40_277 VGND VGND VPWR VPWR sky130_fd_sc_hd__fill_1
X_6133_ clknet_leaf_1_clk _0368_ VGND VGND VPWR VPWR reg_file.memory\[1\]\[3\] sky130_fd_sc_hd__dfxtp_1
X_6202_ clknet_leaf_2_clk _0437_ VGND VGND VPWR VPWR reg_file.memory\[25\]\[8\] sky130_fd_sc_hd__dfxtp_1
X_3276_ _0936_ _0940_ _0611_ VGND VGND VPWR VPWR _0941_ sky130_fd_sc_hd__o21a_1
XFILLER_0_0_363 VGND VGND VPWR VPWR sky130_fd_sc_hd__fill_1
X_3345_ reg_file.memory\[8\]\[9\] reg_file.memory\[9\]\[9\] _0637_ VGND VGND VPWR
+ VPWR _1010_ sky130_fd_sc_hd__mux2_1
XPHY_EDGE_ROW_15_Right_15 VGND VGND VPWR VPWR sky130_fd_sc_hd__decap_3
XFILLER_0_84_85 VPWR VGND VPWR VGND sky130_ef_sc_hd__decap_12
XFILLER_0_84_74 VGND VGND VPWR VPWR sky130_fd_sc_hd__fill_1
XPHY_EDGE_ROW_24_Right_24 VGND VGND VPWR VPWR sky130_fd_sc_hd__decap_3
X_5015_ _2442_ reg_file.memory\[5\]\[16\] _2486_ VGND VGND VPWR VPWR _2493_ sky130_fd_sc_hd__mux2_1
X_5848_ clknet_leaf_16_clk _0098_ VGND VGND VPWR VPWR reg_file.memory\[9\]\[22\] sky130_fd_sc_hd__dfxtp_1
X_5779_ clk_div.slow_clk _0062_ VGND VGND VPWR VPWR seven_seg_conv.temp\[15\] sky130_fd_sc_hd__dfxtp_1
X_5917_ clknet_leaf_24_clk _0152_ VGND VGND VPWR VPWR reg_file.memory\[5\]\[11\] sky130_fd_sc_hd__dfxtp_1
XPHY_EDGE_ROW_33_Right_33 VGND VGND VPWR VPWR sky130_fd_sc_hd__decap_3
XFILLER_0_31_222 VGND VGND VPWR VPWR sky130_fd_sc_hd__fill_2
XTAP_TAPCELL_ROW_59_545 VGND VPWR sky130_fd_sc_hd__tapvpwrvgnd_1
XFILLER_0_66_141 VGND VGND VPWR VPWR sky130_fd_sc_hd__decap_6
XPHY_EDGE_ROW_42_Right_42 VGND VGND VPWR VPWR sky130_fd_sc_hd__decap_3
XTAP_TAPCELL_ROW_42_445 VGND VPWR sky130_fd_sc_hd__tapvpwrvgnd_1
XPHY_EDGE_ROW_51_Right_51 VGND VGND VPWR VPWR sky130_fd_sc_hd__decap_3
X_3130_ _0575_ _0792_ _0794_ _0607_ VGND VGND VPWR VPWR _0795_ sky130_fd_sc_hd__o211a_1
XFILLER_0_38_34 VGND VGND VPWR VPWR sky130_fd_sc_hd__fill_2
XFILLER_0_1_149 VGND VGND VPWR VPWR sky130_fd_sc_hd__fill_1
XPHY_EDGE_ROW_60_Right_60 VGND VGND VPWR VPWR sky130_fd_sc_hd__decap_3
X_3061_ _0574_ _0723_ _0725_ _0606_ VGND VGND VPWR VPWR _0726_ sky130_fd_sc_hd__o211a_1
XFILLER_0_72_144 VPWR VGND VPWR VGND sky130_ef_sc_hd__decap_12
XFILLER_0_72_100 VGND VGND VPWR VPWR sky130_fd_sc_hd__decap_8
XFILLER_0_70_98 VGND VGND VPWR VPWR sky130_fd_sc_hd__fill_1
X_5702_ reg_file.memory\[2\]\[22\] VGND VGND VPWR VPWR _2854_ sky130_fd_sc_hd__clkbuf_1
X_5633_ _2796_ VGND VGND VPWR VPWR _2819_ sky130_fd_sc_hd__buf_4
X_2914_ _0578_ VGND VGND VPWR VPWR _0579_ sky130_fd_sc_hd__buf_2
X_3963_ _1604_ _1617_ _1610_ VGND VGND VPWR VPWR _1619_ sky130_fd_sc_hd__o21ai_1
X_3894_ _1545_ _1547_ _1549_ VGND VGND VPWR VPWR _1550_ sky130_fd_sc_hd__a21o_1
X_4446_ _0974_ _0981_ VGND VGND VPWR VPWR _2080_ sky130_fd_sc_hd__and2b_1
X_4515_ _1215_ _2143_ _1999_ VGND VGND VPWR VPWR _2144_ sky130_fd_sc_hd__o21ai_1
X_5564_ _2759_ VGND VGND VPWR VPWR _2782_ sky130_fd_sc_hd__clkbuf_4
X_5495_ _2745_ VGND VGND VPWR VPWR _0384_ sky130_fd_sc_hd__clkbuf_1
X_4377_ _1038_ _1045_ VGND VGND VPWR VPWR _2015_ sky130_fd_sc_hd__and2b_1
X_6116_ clknet_leaf_21_clk _0351_ VGND VGND VPWR VPWR reg_file.memory\[15\]\[18\]
+ sky130_fd_sc_hd__dfxtp_1
X_6047_ clknet_leaf_25_clk _0282_ VGND VGND VPWR VPWR reg_file.memory\[0\]\[13\] sky130_fd_sc_hd__dfxtp_1
X_3259_ _0573_ _0921_ _0923_ _0606_ VGND VGND VPWR VPWR _0924_ sky130_fd_sc_hd__o211a_1
X_3328_ reg_file.memory\[0\]\[10\] _0992_ _0654_ VGND VGND VPWR VPWR _0993_ sky130_fd_sc_hd__mux2_1
XTAP_TAPCELL_ROW_56_526 VGND VPWR sky130_fd_sc_hd__tapvpwrvgnd_1
XFILLER_0_48_130 VGND VGND VPWR VPWR sky130_fd_sc_hd__decap_3
XFILLER_0_63_188 VGND VGND VPWR VPWR sky130_fd_sc_hd__decap_8
XFILLER_0_63_155 VGND VGND VPWR VPWR sky130_fd_sc_hd__fill_1
XFILLER_0_86_214 VGND VGND VPWR VPWR sky130_fd_sc_hd__fill_1
X_4300_ _1878_ _1941_ _1701_ VGND VGND VPWR VPWR _1942_ sky130_fd_sc_hd__mux2_1
XFILLER_0_49_55 VGND VGND VPWR VPWR sky130_fd_sc_hd__fill_1
X_5280_ _2633_ VGND VGND VPWR VPWR _0281_ sky130_fd_sc_hd__clkbuf_1
X_4162_ _1803_ _1806_ _1687_ VGND VGND VPWR VPWR _1807_ sky130_fd_sc_hd__mux2_1
X_3113_ _0601_ _0777_ VGND VGND VPWR VPWR _0778_ sky130_fd_sc_hd__or2_1
X_4093_ _1293_ _1670_ VGND VGND VPWR VPWR _1739_ sky130_fd_sc_hd__nand2_1
X_4231_ _1157_ _1864_ _1874_ _1875_ VGND VGND VPWR VPWR _1876_ sky130_fd_sc_hd__a211o_1
XFILLER_0_49_88 VGND VGND VPWR VPWR sky130_fd_sc_hd__decap_8
XFILLER_0_10_269 VGND VGND VPWR VPWR sky130_fd_sc_hd__fill_2
XFILLER_0_81_75 VGND VGND VPWR VPWR sky130_fd_sc_hd__fill_1
XFILLER_0_77_225 VGND VGND VPWR VPWR sky130_fd_sc_hd__decap_8
XTAP_TAPCELL_ROW_53_507 VGND VPWR sky130_fd_sc_hd__tapvpwrvgnd_1
X_3044_ reg_file.memory\[0\]\[27\] reg_file.memory\[1\]\[27\] _0593_ VGND VGND VPWR
+ VPWR _0709_ sky130_fd_sc_hd__mux2_1
X_4995_ _2482_ VGND VGND VPWR VPWR _0147_ sky130_fd_sc_hd__clkbuf_1
XFILLER_0_90_3 VGND VGND VPWR VPWR sky130_fd_sc_hd__decap_6
X_5616_ _2810_ VGND VGND VPWR VPWR _0440_ sky130_fd_sc_hd__clkbuf_1
X_3877_ _1523_ _1524_ VGND VGND VPWR VPWR _1533_ sky130_fd_sc_hd__or2_1
X_3946_ _1598_ _1601_ VGND VGND VPWR VPWR _1602_ sky130_fd_sc_hd__nand2_1
XFILLER_0_60_158 VGND VGND VPWR VPWR sky130_fd_sc_hd__decap_4
X_4429_ _1924_ VGND VGND VPWR VPWR _2064_ sky130_fd_sc_hd__buf_2
X_5547_ _2773_ VGND VGND VPWR VPWR _0408_ sky130_fd_sc_hd__clkbuf_1
XFILLER_0_5_296 VPWR VGND VPWR VGND sky130_ef_sc_hd__decap_12
X_5478_ reg_file.memory\[1\]\[11\] VGND VGND VPWR VPWR _2737_ sky130_fd_sc_hd__clkbuf_1
XTAP_TAPCELL_ROW_1_195 VGND VPWR sky130_fd_sc_hd__tapvpwrvgnd_1
XFILLER_0_51_169 VGND VGND VPWR VPWR sky130_fd_sc_hd__decap_8
XTAP_TAPCELL_ROW_75_643 VGND VPWR sky130_fd_sc_hd__tapvpwrvgnd_1
X_3662_ seven_seg_conv.digit_counter\[0\] VGND VGND VPWR VPWR _0020_ sky130_fd_sc_hd__inv_2
XFILLER_0_82_250 VGND VGND VPWR VPWR sky130_fd_sc_hd__fill_2
X_3731_ _1376_ _1346_ _1377_ VGND VGND VPWR VPWR _1387_ sky130_fd_sc_hd__and3_1
Xclkload10 clknet_leaf_22_clk VGND VGND VPWR VPWR clkload10/Y sky130_fd_sc_hd__clkinv_8
X_4780_ _2353_ VGND VGND VPWR VPWR _0061_ sky130_fd_sc_hd__clkbuf_1
X_3800_ _1444_ _1455_ _1367_ VGND VGND VPWR VPWR _1456_ sky130_fd_sc_hd__a21oi_1
Xclkload21 clknet_leaf_8_clk VGND VGND VPWR VPWR clkload21/Y sky130_fd_sc_hd__inv_12
X_3593_ _1255_ _1257_ _0665_ VGND VGND VPWR VPWR _1258_ sky130_fd_sc_hd__mux2_1
X_5401_ _2697_ VGND VGND VPWR VPWR _0338_ sky130_fd_sc_hd__clkbuf_1
X_5263_ reg_file.memory\[0\]\[4\] VGND VGND VPWR VPWR _2625_ sky130_fd_sc_hd__clkbuf_1
XPHY_EDGE_ROW_10_Left_101 VGND VGND VPWR VPWR sky130_fd_sc_hd__decap_3
X_5332_ _2660_ VGND VGND VPWR VPWR _0306_ sky130_fd_sc_hd__clkbuf_1
X_4145_ _1768_ _1780_ _1781_ _1790_ _1658_ VGND VGND VPWR VPWR _1791_ sky130_fd_sc_hd__a221o_1
X_4076_ _1659_ _1721_ VGND VGND VPWR VPWR _1722_ sky130_fd_sc_hd__nand2_1
X_4214_ _1857_ _1858_ VGND VGND VPWR VPWR _1859_ sky130_fd_sc_hd__and2_1
X_5194_ _2589_ VGND VGND VPWR VPWR _0239_ sky130_fd_sc_hd__clkbuf_1
X_3027_ reg_file.memory\[4\]\[28\] reg_file.memory\[5\]\[28\] _0594_ VGND VGND VPWR
+ VPWR _0692_ sky130_fd_sc_hd__mux2_1
XTAP_TAPCELL_ROW_81_679 VGND VPWR sky130_fd_sc_hd__tapvpwrvgnd_1
X_4978_ _2367_ reg_file.memory\[4\]\[31\] _2408_ VGND VGND VPWR VPWR _2473_ sky130_fd_sc_hd__mux2_1
XFILLER_0_25_90 VGND VGND VPWR VPWR sky130_fd_sc_hd__fill_2
Xclkload4 clknet_leaf_16_clk VGND VGND VPWR VPWR clkload4/Y sky130_fd_sc_hd__clkinvlp_4
X_3929_ alu.ALUResult\[5\] seven_seg_conv.temp\[5\] _1352_ VGND VGND VPWR VPWR _1585_
+ sky130_fd_sc_hd__mux2_1
XTAP_TAPCELL_ROW_89_724 VGND VPWR sky130_fd_sc_hd__tapvpwrvgnd_1
XTAP_TAPCELL_ROW_72_624 VGND VPWR sky130_fd_sc_hd__tapvpwrvgnd_1
XTAP_TAPCELL_ROW_29_367 VGND VPWR sky130_fd_sc_hd__tapvpwrvgnd_1
XFILLER_0_24_158 VGND VGND VPWR VPWR sky130_fd_sc_hd__fill_2
X_5881_ clknet_leaf_0_clk _0116_ VGND VGND VPWR VPWR reg_file.memory\[4\]\[7\] sky130_fd_sc_hd__dfxtp_1
X_5950_ clknet_leaf_24_clk _0185_ VGND VGND VPWR VPWR reg_file.memory\[6\]\[12\] sky130_fd_sc_hd__dfxtp_1
X_4832_ reg_file.memory\[9\]\[11\] VGND VGND VPWR VPWR _2380_ sky130_fd_sc_hd__clkbuf_1
X_4901_ alu.ALUResult\[6\] VGND VGND VPWR VPWR _2421_ sky130_fd_sc_hd__buf_1
X_4694_ clk_div.counter\[11\] clk_div.counter\[10\] clk_div.counter\[13\] clk_div.counter\[12\]
+ VGND VGND VPWR VPWR _2300_ sky130_fd_sc_hd__or4bb_1
XFILLER_0_55_272 VGND VGND VPWR VPWR sky130_fd_sc_hd__fill_1
XFILLER_0_55_250 VGND VGND VPWR VPWR sky130_fd_sc_hd__decap_6
X_3645_ _1219_ _1309_ VGND VGND VPWR VPWR _1310_ sky130_fd_sc_hd__xnor2_1
X_4763_ _1556_ _1558_ _2341_ VGND VGND VPWR VPWR _2344_ sky130_fd_sc_hd__a21o_1
X_3714_ seven_seg_conv.temp\[24\] alu.ALUResult\[24\] _1346_ VGND VGND VPWR VPWR _1370_
+ sky130_fd_sc_hd__mux2_1
XPHY_EDGE_ROW_89_Right_89 VGND VGND VPWR VPWR sky130_fd_sc_hd__decap_3
X_5246_ _2616_ VGND VGND VPWR VPWR _0264_ sky130_fd_sc_hd__clkbuf_1
XTAP_TAPCELL_ROW_86_705 VGND VPWR sky130_fd_sc_hd__tapvpwrvgnd_1
X_5315_ reg_file.memory\[0\]\[30\] VGND VGND VPWR VPWR _2651_ sky130_fd_sc_hd__clkbuf_1
X_3576_ _0706_ _1238_ _1240_ VGND VGND VPWR VPWR _1241_ sky130_fd_sc_hd__a21o_1
X_4059_ _1688_ _1702_ _1704_ VGND VGND VPWR VPWR _1705_ sky130_fd_sc_hd__mux2_1
X_5177_ _2467_ reg_file.memory\[7\]\[28\] _2570_ VGND VGND VPWR VPWR _2579_ sky130_fd_sc_hd__mux2_1
X_4128_ _1098_ _1670_ VGND VGND VPWR VPWR _1774_ sky130_fd_sc_hd__nand2_1
XTAP_TAPCELL_ROW_34_392 VGND VPWR sky130_fd_sc_hd__tapvpwrvgnd_1
XTAP_TAPCELL_ROW_26_348 VGND VPWR sky130_fd_sc_hd__tapvpwrvgnd_1
XFILLER_0_52_253 VGND VGND VPWR VPWR sky130_fd_sc_hd__fill_1
XFILLER_0_37_272 VGND VGND VPWR VPWR sky130_fd_sc_hd__fill_2
X_5100_ _2538_ VGND VGND VPWR VPWR _0196_ sky130_fd_sc_hd__clkbuf_1
X_5031_ _2501_ VGND VGND VPWR VPWR _0164_ sky130_fd_sc_hd__clkbuf_1
X_3292_ _0952_ _0956_ _0610_ VGND VGND VPWR VPWR _0957_ sky130_fd_sc_hd__o21a_1
X_6080_ clknet_leaf_20_clk _0315_ VGND VGND VPWR VPWR reg_file.memory\[10\]\[14\]
+ sky130_fd_sc_hd__dfxtp_1
X_3361_ reg_file.memory\[8\]\[8\] reg_file.memory\[9\]\[8\] _0637_ VGND VGND VPWR
+ VPWR _1026_ sky130_fd_sc_hd__mux2_1
X_3430_ reg_file.memory\[8\]\[4\] reg_file.memory\[9\]\[4\] _0635_ VGND VGND VPWR
+ VPWR _1095_ sky130_fd_sc_hd__mux2_1
XFILLER_0_20_183 VGND VGND VPWR VPWR sky130_fd_sc_hd__fill_1
XFILLER_0_90_337 VGND VGND VPWR VPWR sky130_fd_sc_hd__fill_2
XFILLER_0_75_334 VGND VGND VPWR VPWR sky130_fd_sc_hd__fill_2
X_5933_ clknet_leaf_11_clk _0168_ VGND VGND VPWR VPWR reg_file.memory\[5\]\[27\] sky130_fd_sc_hd__dfxtp_1
X_5795_ _0516_ _0014_ VGND VGND VPWR VPWR alu.ALUResult\[1\] sky130_fd_sc_hd__dlxtn_2
X_5864_ clk_div.slow_clk _0006_ VGND VGND VPWR VPWR net17 sky130_fd_sc_hd__dfxtp_1
XFILLER_0_7_111 VGND VGND VPWR VPWR sky130_fd_sc_hd__fill_1
X_4815_ _2371_ VGND VGND VPWR VPWR _0078_ sky130_fd_sc_hd__clkbuf_1
XTAP_TAPCELL_ROW_23_329 VGND VPWR sky130_fd_sc_hd__tapvpwrvgnd_1
X_4677_ _0020_ seven_seg_conv.digit_counter\[1\] VGND VGND VPWR VPWR _2291_ sky130_fd_sc_hd__nand2_1
X_3628_ _1165_ _1174_ VGND VGND VPWR VPWR _1293_ sky130_fd_sc_hd__nor2_1
XFILLER_0_43_220 VGND VGND VPWR VPWR sky130_fd_sc_hd__decap_4
X_4746_ _2333_ VGND VGND VPWR VPWR _0047_ sky130_fd_sc_hd__clkbuf_1
Xoutput17 net17 VGND VGND VPWR VPWR cx[7] sky130_fd_sc_hd__buf_1
X_3559_ _0822_ _1222_ _1223_ VGND VGND VPWR VPWR _1224_ sky130_fd_sc_hd__a21o_1
X_5229_ _2607_ VGND VGND VPWR VPWR _0256_ sky130_fd_sc_hd__clkbuf_1
XFILLER_0_34_286 VGND VGND VPWR VPWR sky130_fd_sc_hd__decap_4
XFILLER_0_34_253 VGND VGND VPWR VPWR sky130_fd_sc_hd__decap_8
XFILLER_0_34_297 VGND VGND VPWR VPWR sky130_fd_sc_hd__fill_2
XFILLER_0_84_153 VGND VGND VPWR VPWR sky130_fd_sc_hd__fill_2
X_2930_ _0594_ VGND VGND VPWR VPWR _0595_ sky130_fd_sc_hd__clkbuf_4
X_4600_ _2060_ _2138_ VGND VGND VPWR VPWR _2221_ sky130_fd_sc_hd__nor2_1
X_4531_ _2115_ _2157_ _1789_ VGND VGND VPWR VPWR _2158_ sky130_fd_sc_hd__mux2_1
X_5580_ _2790_ VGND VGND VPWR VPWR _0424_ sky130_fd_sc_hd__clkbuf_1
X_4462_ _2093_ _2094_ _1999_ VGND VGND VPWR VPWR _2095_ sky130_fd_sc_hd__and3b_1
X_6201_ clknet_leaf_2_clk _0436_ VGND VGND VPWR VPWR reg_file.memory\[25\]\[7\] sky130_fd_sc_hd__dfxtp_1
XFILLER_0_25_220 VGND VGND VPWR VPWR sky130_fd_sc_hd__fill_1
X_3413_ _1075_ _1077_ _0663_ VGND VGND VPWR VPWR _1078_ sky130_fd_sc_hd__mux2_1
XFILLER_0_7_57 VPWR VGND VPWR VGND sky130_ef_sc_hd__decap_12
X_6063_ clknet_leaf_10_clk _0298_ VGND VGND VPWR VPWR reg_file.memory\[0\]\[29\] sky130_fd_sc_hd__dfxtp_1
X_6132_ clknet_leaf_4_clk _0367_ VGND VGND VPWR VPWR reg_file.memory\[1\]\[2\] sky130_fd_sc_hd__dfxtp_1
X_4393_ _1022_ _1029_ VGND VGND VPWR VPWR _2030_ sky130_fd_sc_hd__and2b_1
X_5014_ _2492_ VGND VGND VPWR VPWR _0156_ sky130_fd_sc_hd__clkbuf_1
X_3275_ _0572_ _0937_ _0939_ _0606_ VGND VGND VPWR VPWR _0940_ sky130_fd_sc_hd__o211a_1
X_3344_ reg_file.memory\[0\]\[9\] _1008_ _0654_ VGND VGND VPWR VPWR _1009_ sky130_fd_sc_hd__mux2_1
XFILLER_0_84_97 VPWR VGND VPWR VGND sky130_ef_sc_hd__decap_12
X_5916_ clknet_leaf_24_clk _0151_ VGND VGND VPWR VPWR reg_file.memory\[5\]\[10\] sky130_fd_sc_hd__dfxtp_1
XFILLER_0_90_167 VGND VGND VPWR VPWR sky130_fd_sc_hd__fill_1
X_4729_ clk_div.counter\[12\] _2321_ _2302_ VGND VGND VPWR VPWR _2323_ sky130_fd_sc_hd__a21boi_1
XFILLER_0_63_315 VGND VGND VPWR VPWR sky130_fd_sc_hd__fill_1
X_5847_ clknet_leaf_16_clk _0097_ VGND VGND VPWR VPWR reg_file.memory\[9\]\[21\] sky130_fd_sc_hd__dfxtp_1
X_5778_ clk_div.slow_clk _0061_ VGND VGND VPWR VPWR seven_seg_conv.temp\[14\] sky130_fd_sc_hd__dfxtp_1
XTAP_TAPCELL_ROW_59_546 VGND VPWR sky130_fd_sc_hd__tapvpwrvgnd_1
XPHY_EDGE_ROW_48_Left_139 VGND VGND VPWR VPWR sky130_fd_sc_hd__decap_3
XTAP_TAPCELL_ROW_67_590 VGND VPWR sky130_fd_sc_hd__tapvpwrvgnd_1
XFILLER_0_81_178 VGND VGND VPWR VPWR sky130_fd_sc_hd__decap_3
XPHY_EDGE_ROW_57_Left_148 VGND VGND VPWR VPWR sky130_fd_sc_hd__decap_3
XTAP_TAPCELL_ROW_50_490 VGND VPWR sky130_fd_sc_hd__tapvpwrvgnd_1
XFILLER_0_22_256 VGND VGND VPWR VPWR sky130_fd_sc_hd__fill_2
XPHY_EDGE_ROW_66_Left_157 VGND VGND VPWR VPWR sky130_fd_sc_hd__decap_3
X_3060_ _0600_ _0724_ VGND VGND VPWR VPWR _0725_ sky130_fd_sc_hd__or2_1
XFILLER_0_9_206 VGND VGND VPWR VPWR sky130_fd_sc_hd__fill_1
XPHY_EDGE_ROW_75_Left_166 VGND VGND VPWR VPWR sky130_fd_sc_hd__decap_3
XFILLER_0_72_156 VPWR VGND VPWR VGND sky130_ef_sc_hd__decap_12
X_2913_ _0576_ _0577_ _0569_ VGND VGND VPWR VPWR _0578_ sky130_fd_sc_hd__o21a_1
X_5701_ _2853_ VGND VGND VPWR VPWR _0482_ sky130_fd_sc_hd__clkbuf_1
X_5632_ _2818_ VGND VGND VPWR VPWR _0448_ sky130_fd_sc_hd__clkbuf_1
X_5563_ _2781_ VGND VGND VPWR VPWR _0416_ sky130_fd_sc_hd__clkbuf_1
X_3962_ _1615_ _1613_ _1616_ _1617_ VGND VGND VPWR VPWR _1618_ sky130_fd_sc_hd__a2bb2o_1
X_3893_ _1546_ _1548_ VGND VGND VPWR VPWR _1549_ sky130_fd_sc_hd__nor2_1
X_4445_ _1280_ _2059_ VGND VGND VPWR VPWR _2079_ sky130_fd_sc_hd__nor2_1
X_4376_ _1288_ _1994_ _2000_ _2014_ VGND VGND VPWR VPWR _0534_ sky130_fd_sc_hd__a211o_1
X_4514_ _0903_ _2123_ _2142_ VGND VGND VPWR VPWR _2143_ sky130_fd_sc_hd__a21o_1
X_5494_ reg_file.memory\[1\]\[19\] VGND VGND VPWR VPWR _2745_ sky130_fd_sc_hd__clkbuf_1
XPHY_EDGE_ROW_84_Left_175 VGND VGND VPWR VPWR sky130_fd_sc_hd__decap_3
XTAP_TAPCELL_ROW_56_527 VGND VPWR sky130_fd_sc_hd__tapvpwrvgnd_1
X_3189_ _0846_ _0853_ VGND VGND VPWR VPWR _0854_ sky130_fd_sc_hd__nand2_1
X_6115_ clknet_leaf_21_clk _0350_ VGND VGND VPWR VPWR reg_file.memory\[15\]\[17\]
+ sky130_fd_sc_hd__dfxtp_1
X_3258_ _0599_ _0922_ VGND VGND VPWR VPWR _0923_ sky130_fd_sc_hd__or2_1
X_6046_ clknet_leaf_21_clk _0281_ VGND VGND VPWR VPWR reg_file.memory\[0\]\[12\] sky130_fd_sc_hd__dfxtp_1
X_3327_ reg_file.memory\[5\]\[10\] _0991_ _0646_ VGND VGND VPWR VPWR _0992_ sky130_fd_sc_hd__mux2_1
XFILLER_0_48_175 VGND VGND VPWR VPWR sky130_fd_sc_hd__fill_1
XFILLER_0_48_153 VGND VGND VPWR VPWR sky130_fd_sc_hd__decap_8
XFILLER_0_63_167 VGND VGND VPWR VPWR sky130_fd_sc_hd__fill_1
XFILLER_0_63_145 VGND VGND VPWR VPWR sky130_fd_sc_hd__fill_1
XFILLER_0_48_197 VGND VGND VPWR VPWR sky130_fd_sc_hd__decap_6
XFILLER_0_5_3 VPWR VGND VPWR VGND sky130_ef_sc_hd__decap_12
XFILLER_0_54_112 VGND VGND VPWR VPWR sky130_fd_sc_hd__fill_2
XFILLER_0_42_307 VGND VGND VPWR VPWR sky130_fd_sc_hd__fill_1
XFILLER_0_27_337 VGND VGND VPWR VPWR sky130_fd_sc_hd__fill_1
XFILLER_0_6_209 VGND VGND VPWR VPWR sky130_fd_sc_hd__decap_3
X_4230_ _1655_ _1794_ VGND VGND VPWR VPWR _1875_ sky130_fd_sc_hd__or2_1
X_3112_ reg_file.memory\[0\]\[23\] reg_file.memory\[1\]\[23\] _0595_ VGND VGND VPWR
+ VPWR _0777_ sky130_fd_sc_hd__mux2_1
X_4092_ _1737_ VGND VGND VPWR VPWR _1738_ sky130_fd_sc_hd__clkbuf_4
X_4161_ _1804_ _1805_ VGND VGND VPWR VPWR _1806_ sky130_fd_sc_hd__nand2_1
XFILLER_0_65_88 VGND VGND VPWR VPWR sky130_fd_sc_hd__fill_1
X_3043_ reg_file.memory\[4\]\[27\] reg_file.memory\[5\]\[27\] _0594_ VGND VGND VPWR
+ VPWR _0708_ sky130_fd_sc_hd__mux2_1
XTAP_TAPCELL_ROW_53_508 VGND VPWR sky130_fd_sc_hd__tapvpwrvgnd_1
X_4994_ _2421_ reg_file.memory\[5\]\[6\] _2475_ VGND VGND VPWR VPWR _2482_ sky130_fd_sc_hd__mux2_1
X_3945_ _1595_ _1599_ _1600_ VGND VGND VPWR VPWR _1601_ sky130_fd_sc_hd__and3_1
XFILLER_0_83_3 VGND VGND VPWR VPWR sky130_fd_sc_hd__fill_1
XFILLER_0_60_148 VGND VGND VPWR VPWR sky130_fd_sc_hd__fill_2
XFILLER_0_45_134 VGND VGND VPWR VPWR sky130_fd_sc_hd__fill_1
X_5546_ _2432_ reg_file.memory\[21\]\[11\] _2771_ VGND VGND VPWR VPWR _2773_ sky130_fd_sc_hd__mux2_1
X_5615_ _2432_ reg_file.memory\[25\]\[11\] _2808_ VGND VGND VPWR VPWR _2810_ sky130_fd_sc_hd__mux2_1
X_3876_ _1526_ _1531_ VGND VGND VPWR VPWR _1532_ sky130_fd_sc_hd__and2_1
XFILLER_0_18_359 VGND VGND VPWR VPWR sky130_fd_sc_hd__fill_2
X_4428_ _2006_ _2062_ _1733_ VGND VGND VPWR VPWR _2063_ sky130_fd_sc_hd__mux2_1
X_4359_ _1995_ _1191_ _1996_ VGND VGND VPWR VPWR _1998_ sky130_fd_sc_hd__or3_1
X_5477_ _2736_ VGND VGND VPWR VPWR _0375_ sky130_fd_sc_hd__clkbuf_1
X_6029_ clknet_leaf_9_clk _0264_ VGND VGND VPWR VPWR reg_file.memory\[8\]\[27\] sky130_fd_sc_hd__dfxtp_1
XFILLER_0_68_226 VGND VGND VPWR VPWR sky130_fd_sc_hd__fill_1
XTAP_TAPCELL_ROW_1_196 VGND VPWR sky130_fd_sc_hd__tapvpwrvgnd_1
XFILLER_0_74_207 VGND VGND VPWR VPWR sky130_fd_sc_hd__decap_4
Xclkload22 clknet_leaf_9_clk VGND VGND VPWR VPWR clkload22/X sky130_fd_sc_hd__clkbuf_4
X_3592_ _1256_ reg_file.memory\[10\]\[31\] _0650_ VGND VGND VPWR VPWR _1257_ sky130_fd_sc_hd__mux2_1
X_3661_ _1325_ VGND VGND VPWR VPWR _0013_ sky130_fd_sc_hd__buf_1
XFILLER_0_42_104 VGND VGND VPWR VPWR sky130_fd_sc_hd__fill_1
X_5400_ _2419_ reg_file.memory\[15\]\[5\] _2691_ VGND VGND VPWR VPWR _2697_ sky130_fd_sc_hd__mux2_1
X_3730_ _1381_ _1385_ VGND VGND VPWR VPWR _1386_ sky130_fd_sc_hd__xor2_1
Xclkload11 clknet_leaf_23_clk VGND VGND VPWR VPWR clkload11/Y sky130_fd_sc_hd__clkinv_4
XFILLER_0_27_167 VGND VGND VPWR VPWR sky130_fd_sc_hd__fill_1
X_4213_ _1674_ _1762_ VGND VGND VPWR VPWR _1858_ sky130_fd_sc_hd__nand2_1
X_5262_ _2624_ VGND VGND VPWR VPWR _0272_ sky130_fd_sc_hd__clkbuf_1
XFILLER_0_2_234 VGND VGND VPWR VPWR sky130_fd_sc_hd__fill_1
X_5193_ reg_file.memory\[8\]\[2\] alu.ALUResult\[2\] _2586_ VGND VGND VPWR VPWR _2589_
+ sky130_fd_sc_hd__mux2_1
X_5331_ reg_file.memory\[10\]\[5\] alu.ALUResult\[5\] _2654_ VGND VGND VPWR VPWR _2660_
+ sky130_fd_sc_hd__mux2_1
X_4144_ _1779_ _1785_ _1788_ _1789_ VGND VGND VPWR VPWR _1790_ sky130_fd_sc_hd__o211a_1
X_4075_ _0721_ _1697_ VGND VGND VPWR VPWR _1721_ sky130_fd_sc_hd__nand2_1
X_3026_ reg_file.memory\[7\]\[28\] _0674_ _0601_ reg_file.memory\[2\]\[28\] _0581_
+ VGND VGND VPWR VPWR _0691_ sky130_fd_sc_hd__o221a_1
X_4977_ _2472_ VGND VGND VPWR VPWR _0139_ sky130_fd_sc_hd__clkbuf_1
Xclkload5 clknet_leaf_17_clk VGND VGND VPWR VPWR clkload5/Y sky130_fd_sc_hd__inv_8
X_3928_ _1581_ _1583_ VGND VGND VPWR VPWR _1584_ sky130_fd_sc_hd__or2_1
X_5529_ _2415_ reg_file.memory\[21\]\[3\] _2760_ VGND VGND VPWR VPWR _2764_ sky130_fd_sc_hd__mux2_1
XFILLER_0_41_181 VGND VGND VPWR VPWR sky130_fd_sc_hd__decap_6
X_3859_ _1361_ _1514_ VGND VGND VPWR VPWR _1515_ sky130_fd_sc_hd__xnor2_1
XTAP_TAPCELL_ROW_89_725 VGND VPWR sky130_fd_sc_hd__tapvpwrvgnd_1
XTAP_TAPCELL_ROW_72_625 VGND VPWR sky130_fd_sc_hd__tapvpwrvgnd_1
XFILLER_0_64_295 VGND VGND VPWR VPWR sky130_fd_sc_hd__fill_1
XFILLER_0_64_251 VGND VGND VPWR VPWR sky130_fd_sc_hd__fill_1
XFILLER_0_49_281 VGND VGND VPWR VPWR sky130_fd_sc_hd__fill_1
XFILLER_0_1_15 VPWR VGND VPWR VGND sky130_ef_sc_hd__decap_12
XFILLER_0_62_45 VGND VGND VPWR VPWR sky130_fd_sc_hd__fill_2
X_5880_ clknet_leaf_0_clk _0115_ VGND VGND VPWR VPWR reg_file.memory\[4\]\[6\] sky130_fd_sc_hd__dfxtp_1
X_4900_ _2420_ VGND VGND VPWR VPWR _0114_ sky130_fd_sc_hd__clkbuf_1
XFILLER_0_1_48 VGND VGND VPWR VPWR sky130_fd_sc_hd__fill_2
XFILLER_0_7_337 VGND VGND VPWR VPWR sky130_fd_sc_hd__fill_1
X_4831_ _2379_ VGND VGND VPWR VPWR _0086_ sky130_fd_sc_hd__clkbuf_1
X_4762_ _2343_ VGND VGND VPWR VPWR _0053_ sky130_fd_sc_hd__clkbuf_1
X_4693_ clk_div.counter\[15\] clk_div.counter\[14\] clk_div.counter\[17\] clk_div.counter\[16\]
+ VGND VGND VPWR VPWR _2299_ sky130_fd_sc_hd__or4_1
X_3575_ _0690_ _1239_ VGND VGND VPWR VPWR _1240_ sky130_fd_sc_hd__nand2_1
X_3644_ _0854_ _1308_ VGND VGND VPWR VPWR _1309_ sky130_fd_sc_hd__nand2_1
X_3713_ seven_seg_conv.temp\[22\] alu.ALUResult\[22\] _1346_ VGND VGND VPWR VPWR _1369_
+ sky130_fd_sc_hd__mux2_1
X_5314_ _2650_ VGND VGND VPWR VPWR _0298_ sky130_fd_sc_hd__clkbuf_1
X_5245_ reg_file.memory\[8\]\[27\] alu.ALUResult\[27\] _2608_ VGND VGND VPWR VPWR
+ _2616_ sky130_fd_sc_hd__mux2_1
XTAP_TAPCELL_ROW_86_706 VGND VPWR sky130_fd_sc_hd__tapvpwrvgnd_1
X_5176_ _2578_ VGND VGND VPWR VPWR _0232_ sky130_fd_sc_hd__clkbuf_1
X_4127_ _1770_ _1772_ VGND VGND VPWR VPWR _1773_ sky130_fd_sc_hd__and2b_1
X_4058_ _1703_ VGND VGND VPWR VPWR _1704_ sky130_fd_sc_hd__clkbuf_4
X_3009_ _0673_ VGND VGND VPWR VPWR _0674_ sky130_fd_sc_hd__clkbuf_8
XTAP_TAPCELL_ROW_26_349 VGND VPWR sky130_fd_sc_hd__tapvpwrvgnd_1
XTAP_TAPCELL_ROW_34_393 VGND VPWR sky130_fd_sc_hd__tapvpwrvgnd_1
XFILLER_0_37_240 VGND VGND VPWR VPWR sky130_fd_sc_hd__fill_1
X_5030_ _2457_ reg_file.memory\[5\]\[23\] _2497_ VGND VGND VPWR VPWR _2501_ sky130_fd_sc_hd__mux2_1
XFILLER_0_57_78 VGND VGND VPWR VPWR sky130_fd_sc_hd__decap_3
X_3360_ reg_file.memory\[0\]\[8\] _1024_ _0654_ VGND VGND VPWR VPWR _1025_ sky130_fd_sc_hd__mux2_1
X_3291_ _0572_ _0953_ _0955_ _0605_ VGND VGND VPWR VPWR _0956_ sky130_fd_sc_hd__o211a_1
X_5932_ clknet_leaf_16_clk _0167_ VGND VGND VPWR VPWR reg_file.memory\[5\]\[26\] sky130_fd_sc_hd__dfxtp_1
XFILLER_0_90_327 VGND VGND VPWR VPWR sky130_fd_sc_hd__fill_2
XFILLER_0_75_324 VGND VGND VPWR VPWR sky130_fd_sc_hd__fill_2
X_5794_ _0505_ _0014_ VGND VGND VPWR VPWR alu.ALUResult\[0\] sky130_fd_sc_hd__dlxtn_2
XFILLER_0_43_243 VGND VGND VPWR VPWR sky130_fd_sc_hd__decap_6
XTAP_TAPCELL_ROW_31_374 VGND VPWR sky130_fd_sc_hd__tapvpwrvgnd_1
X_4745_ seven_seg_conv.temp\[0\] _1621_ _2296_ VGND VGND VPWR VPWR _2333_ sky130_fd_sc_hd__mux2_1
X_5863_ clk_div.slow_clk _0005_ VGND VGND VPWR VPWR net16 sky130_fd_sc_hd__dfxtp_1
XFILLER_0_7_101 VGND VGND VPWR VPWR sky130_fd_sc_hd__decap_3
XFILLER_0_7_167 VGND VGND VPWR VPWR sky130_fd_sc_hd__fill_1
X_4814_ reg_file.memory\[9\]\[2\] VGND VGND VPWR VPWR _2371_ sky130_fd_sc_hd__clkbuf_1
X_4676_ _1261_ _1954_ _2283_ _2290_ VGND VGND VPWR VPWR _0529_ sky130_fd_sc_hd__a211o_1
X_3627_ _1181_ _1182_ VGND VGND VPWR VPWR _1292_ sky130_fd_sc_hd__xnor2_1
X_3558_ _0814_ _0821_ VGND VGND VPWR VPWR _1223_ sky130_fd_sc_hd__nor2_1
X_3489_ _0577_ _0623_ _1144_ VGND VGND VPWR VPWR _1154_ sky130_fd_sc_hd__o21a_2
X_5228_ reg_file.memory\[8\]\[19\] alu.ALUResult\[19\] _2597_ VGND VGND VPWR VPWR
+ _2607_ sky130_fd_sc_hd__mux2_1
X_5159_ _2569_ VGND VGND VPWR VPWR _0224_ sky130_fd_sc_hd__clkbuf_1
XFILLER_0_78_195 VGND VGND VPWR VPWR sky130_fd_sc_hd__fill_1
XFILLER_0_34_232 VGND VGND VPWR VPWR sky130_fd_sc_hd__fill_1
XFILLER_0_19_295 VGND VGND VPWR VPWR sky130_fd_sc_hd__fill_1
Xclkbuf_leaf_27_clk clknet_1_0__leaf_clk VGND VGND VPWR VPWR clknet_leaf_27_clk sky130_fd_sc_hd__clkbuf_8
XFILLER_0_84_121 VPWR VGND VPWR VGND sky130_ef_sc_hd__decap_12
XFILLER_0_57_346 VGND VGND VPWR VPWR sky130_fd_sc_hd__fill_2
XFILLER_0_57_335 VGND VGND VPWR VPWR sky130_fd_sc_hd__fill_1
X_6131_ clknet_leaf_5_clk _0366_ VGND VGND VPWR VPWR reg_file.memory\[1\]\[1\] sky130_fd_sc_hd__dfxtp_1
X_4530_ _2136_ _2156_ _1819_ VGND VGND VPWR VPWR _2157_ sky130_fd_sc_hd__mux2_1
X_4392_ _1299_ _1994_ _2018_ _2029_ VGND VGND VPWR VPWR _0535_ sky130_fd_sc_hd__a211o_1
X_4461_ _2092_ _1277_ _2081_ VGND VGND VPWR VPWR _2094_ sky130_fd_sc_hd__or3_1
X_6200_ clknet_leaf_0_clk _0435_ VGND VGND VPWR VPWR reg_file.memory\[25\]\[6\] sky130_fd_sc_hd__dfxtp_1
XFILLER_0_0_321 VGND VGND VPWR VPWR sky130_fd_sc_hd__fill_2
XFILLER_0_7_69 VPWR VGND VPWR VGND sky130_ef_sc_hd__decap_12
X_3412_ _1076_ reg_file.memory\[10\]\[5\] _0645_ VGND VGND VPWR VPWR _1077_ sky130_fd_sc_hd__mux2_1
X_6062_ clknet_leaf_9_clk _0297_ VGND VGND VPWR VPWR reg_file.memory\[0\]\[28\] sky130_fd_sc_hd__dfxtp_1
X_5013_ _2440_ reg_file.memory\[5\]\[15\] _2486_ VGND VGND VPWR VPWR _2492_ sky130_fd_sc_hd__mux2_1
X_3274_ _0599_ _0938_ VGND VGND VPWR VPWR _0939_ sky130_fd_sc_hd__or2_1
X_3343_ reg_file.memory\[5\]\[9\] _1007_ _0645_ VGND VGND VPWR VPWR _1008_ sky130_fd_sc_hd__mux2_1
X_5846_ clknet_leaf_17_clk _0096_ VGND VGND VPWR VPWR reg_file.memory\[9\]\[20\] sky130_fd_sc_hd__dfxtp_1
X_5915_ clknet_leaf_24_clk _0150_ VGND VGND VPWR VPWR reg_file.memory\[5\]\[9\] sky130_fd_sc_hd__dfxtp_1
XPHY_EDGE_ROW_5_Right_5 VGND VGND VPWR VPWR sky130_fd_sc_hd__decap_3
Xclkbuf_leaf_18_clk clknet_1_0__leaf_clk VGND VGND VPWR VPWR clknet_leaf_18_clk sky130_fd_sc_hd__clkbuf_8
X_4659_ _1779_ _1712_ _1715_ _1767_ VGND VGND VPWR VPWR _2275_ sky130_fd_sc_hd__a31o_1
X_4728_ _2321_ _2322_ VGND VGND VPWR VPWR _0040_ sky130_fd_sc_hd__nor2_1
X_2989_ _0653_ VGND VGND VPWR VPWR _0654_ sky130_fd_sc_hd__clkbuf_4
X_5777_ clk_div.slow_clk _0060_ VGND VGND VPWR VPWR seven_seg_conv.temp\[13\] sky130_fd_sc_hd__dfxtp_1
XFILLER_0_31_279 VGND VGND VPWR VPWR sky130_fd_sc_hd__fill_1
XTAP_TAPCELL_ROW_67_591 VGND VPWR sky130_fd_sc_hd__tapvpwrvgnd_1
XTAP_TAPCELL_ROW_59_547 VGND VPWR sky130_fd_sc_hd__tapvpwrvgnd_1
XFILLER_0_66_176 VGND VGND VPWR VPWR sky130_fd_sc_hd__decap_8
XFILLER_0_66_165 VGND VGND VPWR VPWR sky130_fd_sc_hd__fill_2
XFILLER_0_54_327 VGND VGND VPWR VPWR sky130_fd_sc_hd__fill_2
XTAP_TAPCELL_ROW_50_491 VGND VPWR sky130_fd_sc_hd__tapvpwrvgnd_1
XFILLER_0_89_279 VGND VGND VPWR VPWR sky130_fd_sc_hd__fill_1
XFILLER_0_89_268 VGND VGND VPWR VPWR sky130_fd_sc_hd__fill_2
X_2912_ _0549_ PC\[1\] _0541_ _0558_ VGND VGND VPWR VPWR _0577_ sky130_fd_sc_hd__o211a_2
XFILLER_0_57_121 VGND VGND VPWR VPWR sky130_fd_sc_hd__fill_2
XFILLER_0_57_110 VGND VGND VPWR VPWR sky130_fd_sc_hd__fill_2
X_5700_ reg_file.memory\[2\]\[21\] VGND VGND VPWR VPWR _2853_ sky130_fd_sc_hd__clkbuf_1
X_3961_ _1354_ _1611_ VGND VGND VPWR VPWR _1617_ sky130_fd_sc_hd__nor2_1
X_4513_ _0893_ _0900_ VGND VGND VPWR VPWR _2142_ sky130_fd_sc_hd__and2b_1
X_5631_ _2448_ reg_file.memory\[25\]\[19\] _2808_ VGND VGND VPWR VPWR _2818_ sky130_fd_sc_hd__mux2_1
X_5562_ _2448_ reg_file.memory\[21\]\[19\] _2771_ VGND VGND VPWR VPWR _2781_ sky130_fd_sc_hd__mux2_1
X_3892_ _1543_ _1540_ VGND VGND VPWR VPWR _1548_ sky130_fd_sc_hd__nand2_1
XFILLER_0_79_98 VPWR VGND VPWR VGND sky130_ef_sc_hd__decap_12
Xclkbuf_leaf_7_clk clknet_1_1__leaf_clk VGND VGND VPWR VPWR clknet_leaf_7_clk sky130_fd_sc_hd__clkbuf_8
X_4444_ _1744_ _2075_ _2076_ _2077_ _2001_ VGND VGND VPWR VPWR _2078_ sky130_fd_sc_hd__o32a_1
X_4375_ _2001_ _2004_ _2013_ _1797_ VGND VGND VPWR VPWR _2014_ sky130_fd_sc_hd__o211a_1
X_6114_ clknet_leaf_21_clk _0349_ VGND VGND VPWR VPWR reg_file.memory\[15\]\[16\]
+ sky130_fd_sc_hd__dfxtp_1
XFILLER_0_13_279 VGND VGND VPWR VPWR sky130_fd_sc_hd__fill_1
X_5493_ _2744_ VGND VGND VPWR VPWR _0383_ sky130_fd_sc_hd__clkbuf_1
XFILLER_0_21_290 VGND VGND VPWR VPWR sky130_fd_sc_hd__decap_8
X_3326_ reg_file.memory\[6\]\[10\] reg_file.memory\[7\]\[10\] _0637_ VGND VGND VPWR
+ VPWR _0991_ sky130_fd_sc_hd__mux2_1
XTAP_TAPCELL_ROW_56_528 VGND VPWR sky130_fd_sc_hd__tapvpwrvgnd_1
X_3188_ reg_file.memory\[25\]\[19\] _0852_ _0670_ VGND VGND VPWR VPWR _0853_ sky130_fd_sc_hd__mux2_2
X_3257_ reg_file.memory\[0\]\[14\] reg_file.memory\[1\]\[14\] _0592_ VGND VGND VPWR
+ VPWR _0922_ sky130_fd_sc_hd__mux2_1
X_6045_ clknet_leaf_24_clk _0280_ VGND VGND VPWR VPWR reg_file.memory\[0\]\[11\] sky130_fd_sc_hd__dfxtp_1
XTAP_TAPCELL_ROW_64_572 VGND VPWR sky130_fd_sc_hd__tapvpwrvgnd_1
XFILLER_0_63_113 VPWR VGND VPWR VGND sky130_ef_sc_hd__decap_12
XFILLER_0_8_251 VGND VGND VPWR VPWR sky130_fd_sc_hd__fill_1
X_5829_ clknet_leaf_27_clk _0079_ VGND VGND VPWR VPWR reg_file.memory\[9\]\[3\] sky130_fd_sc_hd__dfxtp_1
X_4160_ _1682_ _1680_ VGND VGND VPWR VPWR _1805_ sky130_fd_sc_hd__nand2_1
XFILLER_0_49_57 VGND VGND VPWR VPWR sky130_fd_sc_hd__fill_2
XFILLER_0_49_46 VGND VGND VPWR VPWR sky130_fd_sc_hd__fill_2
X_3111_ reg_file.memory\[4\]\[23\] reg_file.memory\[5\]\[23\] _0595_ VGND VGND VPWR
+ VPWR _0776_ sky130_fd_sc_hd__mux2_1
X_4091_ _1732_ VGND VGND VPWR VPWR _1737_ sky130_fd_sc_hd__clkbuf_4
X_3042_ reg_file.memory\[2\]\[27\] _0567_ _0574_ reg_file.memory\[7\]\[27\] _0581_
+ VGND VGND VPWR VPWR _0707_ sky130_fd_sc_hd__o221a_1
XTAP_TAPCELL_ROW_53_509 VGND VPWR sky130_fd_sc_hd__tapvpwrvgnd_1
X_4993_ _2481_ VGND VGND VPWR VPWR _0146_ sky130_fd_sc_hd__clkbuf_1
X_3875_ _1529_ _1530_ VGND VGND VPWR VPWR _1531_ sky130_fd_sc_hd__nand2_1
X_3944_ _1355_ _1594_ _1592_ VGND VGND VPWR VPWR _1600_ sky130_fd_sc_hd__or3_1
XFILLER_0_14_71 VGND VGND VPWR VPWR sky130_fd_sc_hd__decap_6
XTAP_TAPCELL_ROW_18_296 VGND VPWR sky130_fd_sc_hd__tapvpwrvgnd_1
XFILLER_0_60_116 VGND VGND VPWR VPWR sky130_fd_sc_hd__decap_4
XFILLER_0_41_363 VGND VGND VPWR VPWR sky130_fd_sc_hd__fill_1
XFILLER_0_33_319 VGND VGND VPWR VPWR sky130_fd_sc_hd__fill_1
X_5614_ _2809_ VGND VGND VPWR VPWR _0439_ sky130_fd_sc_hd__clkbuf_1
X_5545_ _2772_ VGND VGND VPWR VPWR _0407_ sky130_fd_sc_hd__clkbuf_1
X_5476_ reg_file.memory\[1\]\[10\] VGND VGND VPWR VPWR _2736_ sky130_fd_sc_hd__clkbuf_1
XFILLER_0_5_210 VPWR VGND VPWR VGND sky130_ef_sc_hd__decap_12
XFILLER_0_5_254 VGND VGND VPWR VPWR sky130_fd_sc_hd__decap_3
X_4289_ _1839_ _1859_ _1786_ VGND VGND VPWR VPWR _1932_ sky130_fd_sc_hd__mux2_1
X_4427_ _2035_ _2061_ _1686_ VGND VGND VPWR VPWR _2062_ sky130_fd_sc_hd__mux2_1
X_4358_ _1995_ _1996_ _1191_ VGND VGND VPWR VPWR _1997_ sky130_fd_sc_hd__o21a_1
X_3309_ reg_file.memory\[21\]\[11\] _0544_ _0624_ _0973_ VGND VGND VPWR VPWR _0974_
+ sky130_fd_sc_hd__o211ai_2
X_6028_ clknet_leaf_12_clk _0263_ VGND VGND VPWR VPWR reg_file.memory\[8\]\[26\] sky130_fd_sc_hd__dfxtp_1
XTAP_TAPCELL_ROW_1_197 VGND VPWR sky130_fd_sc_hd__tapvpwrvgnd_1
XFILLER_0_51_116 VPWR VGND VPWR VGND sky130_ef_sc_hd__decap_12
XFILLER_0_36_157 VGND VGND VPWR VPWR sky130_fd_sc_hd__fill_2
XFILLER_0_17_360 VGND VGND VPWR VPWR sky130_fd_sc_hd__decap_4
XTAP_TAPCELL_ROW_9_242 VGND VPWR sky130_fd_sc_hd__tapvpwrvgnd_1
XFILLER_0_27_113 VGND VGND VPWR VPWR sky130_fd_sc_hd__fill_1
Xclkload23 clknet_leaf_10_clk VGND VGND VPWR VPWR clkload23/Y sky130_fd_sc_hd__clkinv_4
X_3591_ reg_file.memory\[8\]\[31\] reg_file.memory\[9\]\[31\] _0641_ VGND VGND VPWR
+ VPWR _1256_ sky130_fd_sc_hd__mux2_1
X_3660_ _1261_ _1263_ _1265_ _1324_ VGND VGND VPWR VPWR _1325_ sky130_fd_sc_hd__or4bb_1
X_5330_ _2659_ VGND VGND VPWR VPWR _0305_ sky130_fd_sc_hd__clkbuf_1
Xclkload12 clknet_leaf_24_clk VGND VGND VPWR VPWR clkload12/Y sky130_fd_sc_hd__inv_6
XFILLER_0_23_363 VGND VGND VPWR VPWR sky130_fd_sc_hd__fill_1
X_4143_ _1732_ VGND VGND VPWR VPWR _1789_ sky130_fd_sc_hd__clkbuf_4
XFILLER_0_76_66 VGND VGND VPWR VPWR sky130_fd_sc_hd__fill_1
XFILLER_0_76_44 VGND VGND VPWR VPWR sky130_fd_sc_hd__fill_2
X_4212_ _1165_ _1756_ VGND VGND VPWR VPWR _1857_ sky130_fd_sc_hd__nand2_1
X_5261_ reg_file.memory\[0\]\[3\] VGND VGND VPWR VPWR _2624_ sky130_fd_sc_hd__clkbuf_1
X_5192_ _2588_ VGND VGND VPWR VPWR _0238_ sky130_fd_sc_hd__clkbuf_1
X_4074_ _1713_ _1718_ _1719_ VGND VGND VPWR VPWR _1720_ sky130_fd_sc_hd__mux2_1
X_3025_ _0682_ _0689_ VGND VGND VPWR VPWR _0690_ sky130_fd_sc_hd__nand2_1
X_4976_ _2471_ reg_file.memory\[4\]\[30\] _2408_ VGND VGND VPWR VPWR _2472_ sky130_fd_sc_hd__mux2_1
XFILLER_0_65_208 VGND VGND VPWR VPWR sky130_fd_sc_hd__fill_1
X_3858_ _1508_ _1510_ _1513_ VGND VGND VPWR VPWR _1514_ sky130_fd_sc_hd__a21oi_2
X_3927_ _1569_ _1574_ _1577_ VGND VGND VPWR VPWR _1583_ sky130_fd_sc_hd__and3_1
Xclkload6 clknet_leaf_18_clk VGND VGND VPWR VPWR clkload6/Y sky130_fd_sc_hd__clkinv_4
XFILLER_0_18_157 VGND VGND VPWR VPWR sky130_fd_sc_hd__fill_2
X_5459_ _2727_ VGND VGND VPWR VPWR _0366_ sky130_fd_sc_hd__clkbuf_1
X_5528_ _2763_ VGND VGND VPWR VPWR _0399_ sky130_fd_sc_hd__clkbuf_1
X_3789_ _1426_ _1435_ VGND VGND VPWR VPWR _1445_ sky130_fd_sc_hd__and2_1
XFILLER_0_14_363 VGND VGND VPWR VPWR sky130_fd_sc_hd__fill_1
XTAP_TAPCELL_ROW_89_726 VGND VPWR sky130_fd_sc_hd__tapvpwrvgnd_1
XTAP_TAPCELL_ROW_80_670 VGND VPWR sky130_fd_sc_hd__tapvpwrvgnd_1
XFILLER_0_32_182 VGND VGND VPWR VPWR sky130_fd_sc_hd__decap_3
XFILLER_0_1_27 VGND VGND VPWR VPWR sky130_fd_sc_hd__decap_3
X_4692_ clk_div.counter\[1\] _2297_ clk_div.counter\[0\] clk_div.counter\[4\] VGND
+ VGND VPWR VPWR _2298_ sky130_fd_sc_hd__or4b_1
XFILLER_0_47_219 VGND VGND VPWR VPWR sky130_fd_sc_hd__fill_1
X_4761_ seven_seg_conv.temp\[6\] _1567_ _2334_ VGND VGND VPWR VPWR _2343_ sky130_fd_sc_hd__mux2_1
X_4830_ reg_file.memory\[9\]\[10\] VGND VGND VPWR VPWR _2379_ sky130_fd_sc_hd__clkbuf_1
X_3712_ seven_seg_conv.temp\[21\] alu.ALUResult\[21\] _1346_ VGND VGND VPWR VPWR _1368_
+ sky130_fd_sc_hd__mux2_1
X_5313_ reg_file.memory\[0\]\[29\] VGND VGND VPWR VPWR _2650_ sky130_fd_sc_hd__clkbuf_1
XFILLER_0_70_222 VGND VGND VPWR VPWR sky130_fd_sc_hd__decap_8
X_3574_ _0682_ _0689_ VGND VGND VPWR VPWR _1239_ sky130_fd_sc_hd__or2_1
X_3643_ _1220_ VGND VGND VPWR VPWR _1308_ sky130_fd_sc_hd__inv_2
XTAP_TAPCELL_ROW_86_707 VGND VPWR sky130_fd_sc_hd__tapvpwrvgnd_1
X_4126_ _1674_ _1771_ VGND VGND VPWR VPWR _1772_ sky130_fd_sc_hd__or2_1
X_5175_ _2465_ reg_file.memory\[7\]\[27\] _2570_ VGND VGND VPWR VPWR _2578_ sky130_fd_sc_hd__mux2_1
X_5244_ _2615_ VGND VGND VPWR VPWR _0263_ sky130_fd_sc_hd__clkbuf_1
XFILLER_0_39_3 VGND VGND VPWR VPWR sky130_fd_sc_hd__fill_1
X_3008_ _0538_ _0557_ _0564_ VGND VGND VPWR VPWR _0673_ sky130_fd_sc_hd__o21a_1
X_4057_ _0598_ _0624_ _1127_ VGND VGND VPWR VPWR _1703_ sky130_fd_sc_hd__o21ai_2
X_4959_ _2460_ VGND VGND VPWR VPWR _0133_ sky130_fd_sc_hd__clkbuf_1
XTAP_TAPCELL_ROW_34_394 VGND VPWR sky130_fd_sc_hd__tapvpwrvgnd_1
XFILLER_0_84_336 VGND VGND VPWR VPWR sky130_fd_sc_hd__fill_2
XFILLER_0_52_211 VGND VGND VPWR VPWR sky130_fd_sc_hd__decap_8
XFILLER_0_32_38 VGND VGND VPWR VPWR sky130_fd_sc_hd__decap_8
XPHY_EDGE_ROW_2_Left_93 VGND VGND VPWR VPWR sky130_fd_sc_hd__decap_3
XFILLER_0_20_141 VGND VGND VPWR VPWR sky130_fd_sc_hd__fill_2
X_3290_ _0599_ _0954_ VGND VGND VPWR VPWR _0955_ sky130_fd_sc_hd__or2_1
X_5931_ clknet_leaf_11_clk _0166_ VGND VGND VPWR VPWR reg_file.memory\[5\]\[25\] sky130_fd_sc_hd__dfxtp_1
X_5862_ clk_div.slow_clk _0004_ VGND VGND VPWR VPWR net15 sky130_fd_sc_hd__dfxtp_1
X_4744_ clk_div.counter\[17\] _2330_ VGND VGND VPWR VPWR _0046_ sky130_fd_sc_hd__xnor2_1
X_5793_ _0013_ _0012_ VGND VGND VPWR VPWR alu.ZERO sky130_fd_sc_hd__dlxtn_1
X_4675_ _1976_ _2118_ _2289_ _1952_ VGND VGND VPWR VPWR _2290_ sky130_fd_sc_hd__o211a_1
XTAP_TAPCELL_ROW_31_375 VGND VPWR sky130_fd_sc_hd__tapvpwrvgnd_1
X_4813_ _2370_ VGND VGND VPWR VPWR _0077_ sky130_fd_sc_hd__clkbuf_1
X_3488_ _1145_ _1152_ VGND VGND VPWR VPWR _1153_ sky130_fd_sc_hd__nand2_1
X_3626_ _1107_ _1118_ VGND VGND VPWR VPWR _1291_ sky130_fd_sc_hd__xnor2_2
X_3557_ _0830_ _0837_ _0838_ _1221_ VGND VGND VPWR VPWR _1222_ sky130_fd_sc_hd__o2bb2a_1
XFILLER_0_43_288 VGND VGND VPWR VPWR sky130_fd_sc_hd__decap_3
XFILLER_0_3_363 VGND VGND VPWR VPWR sky130_fd_sc_hd__fill_1
X_5227_ _2606_ VGND VGND VPWR VPWR _0255_ sky130_fd_sc_hd__clkbuf_1
X_4109_ _1749_ _1754_ _1701_ VGND VGND VPWR VPWR _1755_ sky130_fd_sc_hd__mux2_1
X_5158_ _2448_ reg_file.memory\[7\]\[19\] _2559_ VGND VGND VPWR VPWR _2569_ sky130_fd_sc_hd__mux2_1
X_5089_ _2532_ VGND VGND VPWR VPWR _0191_ sky130_fd_sc_hd__clkbuf_1
XFILLER_0_78_185 VGND VGND VPWR VPWR sky130_fd_sc_hd__fill_1
XFILLER_0_78_141 VPWR VGND VPWR VGND sky130_ef_sc_hd__decap_12
XTAP_TAPCELL_ROW_22_320 VGND VPWR sky130_fd_sc_hd__tapvpwrvgnd_1
XFILLER_0_84_133 VGND VGND VPWR VPWR sky130_fd_sc_hd__decap_6
XFILLER_0_80_350 VGND VGND VPWR VPWR sky130_fd_sc_hd__fill_1
X_4391_ _2001_ _2019_ _2028_ _1797_ VGND VGND VPWR VPWR _2029_ sky130_fd_sc_hd__o211a_1
X_6130_ clknet_leaf_1_clk _0365_ VGND VGND VPWR VPWR reg_file.memory\[1\]\[0\] sky130_fd_sc_hd__dfxtp_1
X_4460_ _2092_ _2081_ _1277_ VGND VGND VPWR VPWR _2093_ sky130_fd_sc_hd__o21a_1
X_3342_ reg_file.memory\[6\]\[9\] reg_file.memory\[7\]\[9\] _0636_ VGND VGND VPWR
+ VPWR _1007_ sky130_fd_sc_hd__mux2_1
XFILLER_0_0_355 VGND VGND VPWR VPWR sky130_fd_sc_hd__decap_8
XFILLER_0_7_15 VGND VGND VPWR VPWR sky130_fd_sc_hd__decap_6
X_3411_ reg_file.memory\[8\]\[5\] reg_file.memory\[9\]\[5\] _0636_ VGND VGND VPWR
+ VPWR _1076_ sky130_fd_sc_hd__mux2_1
X_6061_ clknet_leaf_12_clk _0296_ VGND VGND VPWR VPWR reg_file.memory\[0\]\[27\] sky130_fd_sc_hd__dfxtp_1
X_5012_ _2491_ VGND VGND VPWR VPWR _0155_ sky130_fd_sc_hd__clkbuf_1
X_3273_ reg_file.memory\[0\]\[13\] reg_file.memory\[1\]\[13\] _0591_ VGND VGND VPWR
+ VPWR _0938_ sky130_fd_sc_hd__mux2_1
XFILLER_0_75_177 VGND VGND VPWR VPWR sky130_fd_sc_hd__decap_3
XFILLER_0_48_303 VGND VGND VPWR VPWR sky130_fd_sc_hd__fill_2
X_5914_ clknet_leaf_24_clk _0149_ VGND VGND VPWR VPWR reg_file.memory\[5\]\[8\] sky130_fd_sc_hd__dfxtp_1
X_5845_ clknet_leaf_18_clk _0095_ VGND VGND VPWR VPWR reg_file.memory\[9\]\[19\] sky130_fd_sc_hd__dfxtp_1
XFILLER_0_90_169 VPWR VGND VPWR VGND sky130_ef_sc_hd__decap_12
X_4727_ clk_div.counter\[10\] _2319_ clk_div.counter\[11\] VGND VGND VPWR VPWR _2322_
+ sky130_fd_sc_hd__a21oi_1
X_2988_ _0548_ _0542_ _0633_ _0652_ _0630_ VGND VGND VPWR VPWR _0653_ sky130_fd_sc_hd__o221a_2
X_4658_ _2272_ _2273_ _1999_ VGND VGND VPWR VPWR _2274_ sky130_fd_sc_hd__and3b_1
X_3609_ _1210_ _1273_ VGND VGND VPWR VPWR _1274_ sky130_fd_sc_hd__xor2_1
X_5776_ clk_div.slow_clk _0059_ VGND VGND VPWR VPWR seven_seg_conv.temp\[12\] sky130_fd_sc_hd__dfxtp_1
X_6259_ clk_div.slow_clk _0494_ VGND VGND VPWR VPWR net10 sky130_fd_sc_hd__dfxtp_1
X_4589_ _1673_ _1729_ VGND VGND VPWR VPWR _2211_ sky130_fd_sc_hd__and2_1
XTAP_TAPCELL_ROW_67_592 VGND VPWR sky130_fd_sc_hd__tapvpwrvgnd_1
XFILLER_0_81_147 VGND VGND VPWR VPWR sky130_fd_sc_hd__decap_4
XTAP_TAPCELL_ROW_50_492 VGND VPWR sky130_fd_sc_hd__tapvpwrvgnd_1
XPHY_EDGE_ROW_11_Right_11 VGND VGND VPWR VPWR sky130_fd_sc_hd__decap_3
XPHY_EDGE_ROW_20_Right_20 VGND VGND VPWR VPWR sky130_fd_sc_hd__decap_3
XFILLER_0_22_203 VGND VGND VPWR VPWR sky130_fd_sc_hd__fill_2
XFILLER_0_54_36 VGND VGND VPWR VPWR sky130_fd_sc_hd__fill_1
X_2911_ PC\[4\] VGND VGND VPWR VPWR _0576_ sky130_fd_sc_hd__clkbuf_4
X_3960_ _1604_ _1612_ VGND VGND VPWR VPWR _1616_ sky130_fd_sc_hd__nand2_1
X_3891_ _1542_ _1544_ _1546_ VGND VGND VPWR VPWR _1547_ sky130_fd_sc_hd__a21o_1
XFILLER_0_72_136 VGND VGND VPWR VPWR sky130_fd_sc_hd__decap_4
XFILLER_0_70_79 VGND VGND VPWR VPWR sky130_fd_sc_hd__decap_4
X_4512_ _1305_ _1954_ VGND VGND VPWR VPWR _2141_ sky130_fd_sc_hd__and2_1
X_5561_ _2780_ VGND VGND VPWR VPWR _0415_ sky130_fd_sc_hd__clkbuf_1
X_5630_ _2817_ VGND VGND VPWR VPWR _0447_ sky130_fd_sc_hd__clkbuf_1
X_5492_ reg_file.memory\[1\]\[18\] VGND VGND VPWR VPWR _2744_ sky130_fd_sc_hd__clkbuf_1
X_4443_ _1845_ _1949_ VGND VGND VPWR VPWR _2077_ sky130_fd_sc_hd__and2_1
X_4374_ _1743_ _2008_ _2010_ _2012_ VGND VGND VPWR VPWR _2013_ sky130_fd_sc_hd__or4_1
X_3325_ reg_file.memory\[21\]\[10\] _0544_ _0624_ _0989_ VGND VGND VPWR VPWR _0990_
+ sky130_fd_sc_hd__o211ai_2
X_6113_ clknet_leaf_21_clk _0348_ VGND VGND VPWR VPWR reg_file.memory\[15\]\[15\]
+ sky130_fd_sc_hd__dfxtp_1
XFILLER_0_0_141 VPWR VGND VPWR VGND sky130_ef_sc_hd__decap_12
XFILLER_0_0_174 VPWR VGND VPWR VGND sky130_ef_sc_hd__decap_12
X_3256_ reg_file.memory\[4\]\[14\] reg_file.memory\[5\]\[14\] _0592_ VGND VGND VPWR
+ VPWR _0921_ sky130_fd_sc_hd__mux2_1
X_6044_ clknet_leaf_24_clk _0279_ VGND VGND VPWR VPWR reg_file.memory\[0\]\[10\] sky130_fd_sc_hd__dfxtp_1
XTAP_TAPCELL_ROW_56_529 VGND VPWR sky130_fd_sc_hd__tapvpwrvgnd_1
XFILLER_0_48_111 VGND VGND VPWR VPWR sky130_fd_sc_hd__decap_8
X_3187_ _0849_ _0851_ _0664_ VGND VGND VPWR VPWR _0852_ sky130_fd_sc_hd__mux2_1
XFILLER_0_21_3 VGND VGND VPWR VPWR sky130_fd_sc_hd__fill_2
X_5759_ clknet_leaf_6_clk _0043_ VGND VGND VPWR VPWR clk_div.counter\[14\] sky130_fd_sc_hd__dfxtp_1
XTAP_TAPCELL_ROW_64_573 VGND VPWR sky130_fd_sc_hd__tapvpwrvgnd_1
XFILLER_0_63_169 VPWR VGND VPWR VGND sky130_ef_sc_hd__decap_12
XFILLER_0_63_125 VPWR VGND VPWR VGND sky130_ef_sc_hd__decap_12
XFILLER_0_48_122 VGND VGND VPWR VPWR sky130_fd_sc_hd__fill_1
X_5828_ clknet_leaf_27_clk _0078_ VGND VGND VPWR VPWR reg_file.memory\[9\]\[2\] sky130_fd_sc_hd__dfxtp_1
XFILLER_0_86_206 VGND VGND VPWR VPWR sky130_fd_sc_hd__decap_8
X_3110_ reg_file.memory\[7\]\[23\] _0674_ _0601_ reg_file.memory\[2\]\[23\] _0581_
+ VGND VGND VPWR VPWR _0775_ sky130_fd_sc_hd__o221a_1
XFILLER_0_10_206 VGND VGND VPWR VPWR sky130_fd_sc_hd__decap_3
X_3041_ _0698_ _0705_ VGND VGND VPWR VPWR _0706_ sky130_fd_sc_hd__nand2_1
X_4090_ _1654_ _1735_ VGND VGND VPWR VPWR _1736_ sky130_fd_sc_hd__nand2_1
XTAP_TAPCELL_ROW_61_554 VGND VPWR sky130_fd_sc_hd__tapvpwrvgnd_1
X_5613_ _2429_ reg_file.memory\[25\]\[10\] _2808_ VGND VGND VPWR VPWR _2809_ sky130_fd_sc_hd__mux2_1
X_4992_ _2419_ reg_file.memory\[5\]\[5\] _2475_ VGND VGND VPWR VPWR _2481_ sky130_fd_sc_hd__mux2_1
XFILLER_0_5_222 VGND VGND VPWR VPWR sky130_fd_sc_hd__fill_2
XFILLER_0_5_200 VGND VGND VPWR VPWR sky130_fd_sc_hd__decap_4
X_3874_ _1528_ _1527_ VGND VGND VPWR VPWR _1530_ sky130_fd_sc_hd__or2b_1
X_3943_ _1589_ _1592_ VGND VGND VPWR VPWR _1599_ sky130_fd_sc_hd__nand2_1
XTAP_TAPCELL_ROW_18_297 VGND VPWR sky130_fd_sc_hd__tapvpwrvgnd_1
XFILLER_0_18_339 VGND VGND VPWR VPWR sky130_fd_sc_hd__decap_3
X_4426_ _1855_ _1857_ VGND VGND VPWR VPWR _2061_ sky130_fd_sc_hd__nand2_1
XFILLER_0_69_3 VGND VGND VPWR VPWR sky130_fd_sc_hd__decap_6
XFILLER_0_60_106 VGND VGND VPWR VPWR sky130_fd_sc_hd__fill_1
XFILLER_0_53_191 VPWR VGND VPWR VGND sky130_ef_sc_hd__decap_12
X_5544_ _2429_ reg_file.memory\[21\]\[10\] _2771_ VGND VGND VPWR VPWR _2772_ sky130_fd_sc_hd__mux2_1
XFILLER_0_5_266 VGND VGND VPWR VPWR sky130_fd_sc_hd__fill_1
X_5475_ _2735_ VGND VGND VPWR VPWR _0374_ sky130_fd_sc_hd__clkbuf_1
X_4288_ _1842_ _1930_ _1819_ VGND VGND VPWR VPWR _1931_ sky130_fd_sc_hd__mux2_1
X_6027_ clknet_leaf_11_clk _0262_ VGND VGND VPWR VPWR reg_file.memory\[8\]\[25\] sky130_fd_sc_hd__dfxtp_1
X_4357_ _1978_ _1188_ VGND VGND VPWR VPWR _1996_ sky130_fd_sc_hd__and2b_1
X_3308_ reg_file.memory\[15\]\[11\] _0552_ _0616_ _0972_ VGND VGND VPWR VPWR _0973_
+ sky130_fd_sc_hd__a211o_1
X_3239_ reg_file.memory\[2\]\[15\] _0567_ _0573_ reg_file.memory\[7\]\[15\] _0580_
+ VGND VGND VPWR VPWR _0904_ sky130_fd_sc_hd__o221a_1
XTAP_TAPCELL_ROW_1_198 VGND VPWR sky130_fd_sc_hd__tapvpwrvgnd_1
XFILLER_0_51_128 VPWR VGND VPWR VGND sky130_ef_sc_hd__decap_12
XTAP_TAPCELL_ROW_9_243 VGND VPWR sky130_fd_sc_hd__tapvpwrvgnd_1
XTAP_TAPCELL_ROW_83_690 VGND VPWR sky130_fd_sc_hd__tapvpwrvgnd_1
XFILLER_0_27_169 VGND VGND VPWR VPWR sky130_fd_sc_hd__fill_1
XTAP_TAPCELL_ROW_15_278 VGND VPWR sky130_fd_sc_hd__tapvpwrvgnd_1
X_3590_ reg_file.memory\[0\]\[31\] _1254_ _0656_ VGND VGND VPWR VPWR _1255_ sky130_fd_sc_hd__mux2_1
X_5260_ _2623_ VGND VGND VPWR VPWR _0271_ sky130_fd_sc_hd__clkbuf_1
Xclkload24 clknet_leaf_12_clk VGND VGND VPWR VPWR clkload24/Y sky130_fd_sc_hd__clkinv_4
Xclkload13 clknet_leaf_25_clk VGND VGND VPWR VPWR clkload13/Y sky130_fd_sc_hd__inv_8
X_4142_ _1786_ _1682_ _1787_ VGND VGND VPWR VPWR _1788_ sky130_fd_sc_hd__or3_1
XFILLER_0_76_89 VGND VGND VPWR VPWR sky130_fd_sc_hd__fill_1
X_4073_ _1686_ VGND VGND VPWR VPWR _1719_ sky130_fd_sc_hd__clkbuf_4
X_4211_ _1854_ _1855_ VGND VGND VPWR VPWR _1856_ sky130_fd_sc_hd__nand2_1
X_5191_ reg_file.memory\[8\]\[1\] alu.ALUResult\[1\] _2586_ VGND VGND VPWR VPWR _2588_
+ sky130_fd_sc_hd__mux2_1
X_3024_ reg_file.memory\[25\]\[29\] _0688_ _0671_ VGND VGND VPWR VPWR _0689_ sky130_fd_sc_hd__mux2_1
X_4975_ _1376_ VGND VGND VPWR VPWR _2471_ sky130_fd_sc_hd__dlymetal6s2s_1
XFILLER_0_73_231 VGND VGND VPWR VPWR sky130_fd_sc_hd__decap_4
X_3857_ _1511_ _1512_ VGND VGND VPWR VPWR _1513_ sky130_fd_sc_hd__nor2_1
X_3926_ _1580_ _1577_ _1581_ _1568_ VGND VGND VPWR VPWR _1582_ sky130_fd_sc_hd__o22ai_2
X_3788_ _1441_ _1437_ _1443_ VGND VGND VPWR VPWR _1444_ sky130_fd_sc_hd__mux2_2
Xclkload7 clknet_leaf_19_clk VGND VGND VPWR VPWR clkload7/Y sky130_fd_sc_hd__inv_6
XTAP_TAPCELL_ROW_89_727 VGND VPWR sky130_fd_sc_hd__tapvpwrvgnd_1
X_5458_ reg_file.memory\[1\]\[1\] VGND VGND VPWR VPWR _2727_ sky130_fd_sc_hd__clkbuf_1
X_5527_ _2413_ reg_file.memory\[21\]\[2\] _2760_ VGND VGND VPWR VPWR _2763_ sky130_fd_sc_hd__mux2_1
X_4409_ _1902_ _2044_ VGND VGND VPWR VPWR _2045_ sky130_fd_sc_hd__nor2_1
XFILLER_0_41_150 VGND VGND VPWR VPWR sky130_fd_sc_hd__fill_1
X_5389_ _2690_ VGND VGND VPWR VPWR _2691_ sky130_fd_sc_hd__clkbuf_4
XTAP_TAPCELL_ROW_6_224 VGND VPWR sky130_fd_sc_hd__tapvpwrvgnd_1
XTAP_TAPCELL_ROW_80_671 VGND VPWR sky130_fd_sc_hd__tapvpwrvgnd_1
XFILLER_0_64_253 VPWR VGND VPWR VGND sky130_ef_sc_hd__decap_12
XFILLER_0_56_209 VGND VGND VPWR VPWR sky130_fd_sc_hd__fill_1
XFILLER_0_24_139 VGND VGND VPWR VPWR sky130_fd_sc_hd__fill_1
XFILLER_0_20_334 VPWR VGND VPWR VGND sky130_ef_sc_hd__decap_12
XFILLER_0_21_29 VGND VGND VPWR VPWR sky130_fd_sc_hd__decap_8
XFILLER_0_32_194 VGND VGND VPWR VPWR sky130_fd_sc_hd__fill_2
XFILLER_0_87_334 VGND VGND VPWR VPWR sky130_fd_sc_hd__fill_2
X_4691_ clk_div.counter\[3\] clk_div.counter\[5\] clk_div.counter\[2\] VGND VGND VPWR
+ VPWR _2297_ sky130_fd_sc_hd__or3b_1
X_3642_ _1218_ _1306_ VGND VGND VPWR VPWR _1307_ sky130_fd_sc_hd__or2_1
X_3711_ seven_seg_conv.temp\[20\] alu.ALUResult\[20\] _1346_ VGND VGND VPWR VPWR _1367_
+ sky130_fd_sc_hd__mux2_1
XFILLER_0_11_40 VGND VGND VPWR VPWR sky130_fd_sc_hd__decap_8
X_4760_ _2340_ seven_seg_conv.temp\[5\] _2342_ VGND VGND VPWR VPWR _0052_ sky130_fd_sc_hd__a21o_1
XFILLER_0_15_139 VGND VGND VPWR VPWR sky130_fd_sc_hd__fill_2
X_5312_ _2649_ VGND VGND VPWR VPWR _0297_ sky130_fd_sc_hd__clkbuf_1
X_3573_ _1235_ _1237_ VGND VGND VPWR VPWR _1238_ sky130_fd_sc_hd__nand2_1
XPHY_EDGE_ROW_49_Right_49 VGND VGND VPWR VPWR sky130_fd_sc_hd__decap_3
X_5243_ reg_file.memory\[8\]\[26\] alu.ALUResult\[26\] _2608_ VGND VGND VPWR VPWR
+ _2615_ sky130_fd_sc_hd__mux2_1
XTAP_TAPCELL_ROW_86_708 VGND VPWR sky130_fd_sc_hd__tapvpwrvgnd_1
X_4056_ _1694_ _1700_ _1701_ VGND VGND VPWR VPWR _1702_ sky130_fd_sc_hd__mux2_1
XPHY_EDGE_ROW_58_Right_58 VGND VGND VPWR VPWR sky130_fd_sc_hd__decap_3
X_4125_ _1045_ _1669_ VGND VGND VPWR VPWR _1771_ sky130_fd_sc_hd__nand2_1
X_5174_ _2577_ VGND VGND VPWR VPWR _0231_ sky130_fd_sc_hd__clkbuf_1
X_3007_ reg_file.memory\[25\]\[30\] _0666_ _0671_ VGND VGND VPWR VPWR _0672_ sky130_fd_sc_hd__mux2_1
X_4958_ _2459_ reg_file.memory\[4\]\[24\] _2451_ VGND VGND VPWR VPWR _2460_ sky130_fd_sc_hd__mux2_1
XPHY_EDGE_ROW_67_Right_67 VGND VGND VPWR VPWR sky130_fd_sc_hd__decap_3
X_4889_ alu.ALUResult\[2\] VGND VGND VPWR VPWR _2413_ sky130_fd_sc_hd__buf_1
XTAP_TAPCELL_ROW_34_395 VGND VPWR sky130_fd_sc_hd__tapvpwrvgnd_1
X_3909_ _1554_ _1555_ VGND VGND VPWR VPWR _1565_ sky130_fd_sc_hd__nand2_1
XFILLER_0_6_350 VPWR VGND VPWR VGND sky130_ef_sc_hd__decap_12
XFILLER_0_14_161 VGND VGND VPWR VPWR sky130_fd_sc_hd__fill_1
XFILLER_0_14_150 VGND VGND VPWR VPWR sky130_fd_sc_hd__fill_2
XPHY_EDGE_ROW_76_Right_76 VGND VGND VPWR VPWR sky130_fd_sc_hd__decap_3
XFILLER_0_16_29 VGND VGND VPWR VPWR sky130_fd_sc_hd__fill_2
XPHY_EDGE_ROW_85_Right_85 VGND VGND VPWR VPWR sky130_fd_sc_hd__decap_3
XTAP_TAPCELL_ROW_25_340 VGND VPWR sky130_fd_sc_hd__tapvpwrvgnd_1
XFILLER_0_4_309 VGND VGND VPWR VPWR sky130_fd_sc_hd__fill_1
X_5930_ clknet_leaf_12_clk _0165_ VGND VGND VPWR VPWR reg_file.memory\[5\]\[24\] sky130_fd_sc_hd__dfxtp_1
XTAP_TAPCELL_ROW_48_476 VGND VPWR sky130_fd_sc_hd__tapvpwrvgnd_1
X_5792_ clk_div.slow_clk _0075_ VGND VGND VPWR VPWR seven_seg_conv.temp\[28\] sky130_fd_sc_hd__dfxtp_1
X_5861_ clk_div.slow_clk _0003_ VGND VGND VPWR VPWR net14 sky130_fd_sc_hd__dfxtp_1
X_4812_ reg_file.memory\[9\]\[1\] VGND VGND VPWR VPWR _2370_ sky130_fd_sc_hd__clkbuf_1
XFILLER_0_90_307 VGND VGND VPWR VPWR sky130_fd_sc_hd__fill_1
X_4743_ _2332_ VGND VGND VPWR VPWR _0045_ sky130_fd_sc_hd__clkbuf_1
X_4674_ _1742_ _2287_ _2288_ _2113_ _2135_ VGND VGND VPWR VPWR _2289_ sky130_fd_sc_hd__a2111o_1
X_3625_ _1185_ _1289_ VGND VGND VPWR VPWR _1290_ sky130_fd_sc_hd__and2_1
XTAP_TAPCELL_ROW_31_376 VGND VPWR sky130_fd_sc_hd__tapvpwrvgnd_1
XFILLER_0_28_253 VGND VGND VPWR VPWR sky130_fd_sc_hd__fill_1
XFILLER_0_7_169 VGND VGND VPWR VPWR sky130_fd_sc_hd__fill_1
X_3487_ reg_file.memory\[25\]\[1\] _1151_ _0668_ VGND VGND VPWR VPWR _1152_ sky130_fd_sc_hd__mux2_1
XFILLER_0_51_3 VGND VGND VPWR VPWR sky130_fd_sc_hd__fill_2
X_3556_ _0854_ _1219_ _1220_ VGND VGND VPWR VPWR _1221_ sky130_fd_sc_hd__a21o_1
X_5226_ reg_file.memory\[8\]\[18\] alu.ALUResult\[18\] _2597_ VGND VGND VPWR VPWR
+ _2606_ sky130_fd_sc_hd__mux2_1
XFILLER_0_78_153 VPWR VGND VPWR VGND sky130_ef_sc_hd__decap_12
X_4039_ _1681_ _1684_ VGND VGND VPWR VPWR _1685_ sky130_fd_sc_hd__nand2_1
X_4108_ _1751_ _1753_ VGND VGND VPWR VPWR _1754_ sky130_fd_sc_hd__nand2_1
X_5088_ _2446_ reg_file.memory\[6\]\[18\] _2523_ VGND VGND VPWR VPWR _2532_ sky130_fd_sc_hd__mux2_1
X_5157_ _2568_ VGND VGND VPWR VPWR _0223_ sky130_fd_sc_hd__clkbuf_1
XFILLER_0_78_197 VPWR VGND VPWR VGND sky130_ef_sc_hd__decap_12
XFILLER_0_66_337 VGND VGND VPWR VPWR sky130_fd_sc_hd__fill_2
XTAP_TAPCELL_ROW_22_321 VGND VPWR sky130_fd_sc_hd__tapvpwrvgnd_1
XFILLER_0_34_245 VGND VGND VPWR VPWR sky130_fd_sc_hd__fill_2
XFILLER_0_69_175 VGND VGND VPWR VPWR sky130_fd_sc_hd__fill_1
XFILLER_0_4_128 VGND VGND VPWR VPWR sky130_fd_sc_hd__fill_2
X_4390_ _1744_ _2026_ _2027_ VGND VGND VPWR VPWR _2028_ sky130_fd_sc_hd__or3b_1
X_6060_ clknet_leaf_16_clk _0295_ VGND VGND VPWR VPWR reg_file.memory\[0\]\[26\] sky130_fd_sc_hd__dfxtp_1
X_3341_ reg_file.memory\[21\]\[9\] _0544_ _0624_ _1005_ VGND VGND VPWR VPWR _1006_
+ sky130_fd_sc_hd__o211ai_2
X_3410_ reg_file.memory\[0\]\[5\] _1074_ _0654_ VGND VGND VPWR VPWR _1075_ sky130_fd_sc_hd__mux2_1
XFILLER_0_0_334 VGND VGND VPWR VPWR sky130_fd_sc_hd__fill_2
X_3272_ reg_file.memory\[4\]\[13\] reg_file.memory\[5\]\[13\] _0592_ VGND VGND VPWR
+ VPWR _0937_ sky130_fd_sc_hd__mux2_1
X_5011_ _2438_ reg_file.memory\[5\]\[14\] _2486_ VGND VGND VPWR VPWR _2491_ sky130_fd_sc_hd__mux2_1
XFILLER_0_75_189 VPWR VGND VPWR VGND sky130_ef_sc_hd__decap_12
XFILLER_0_75_167 VGND VGND VPWR VPWR sky130_fd_sc_hd__fill_1
X_2987_ _0568_ VGND VGND VPWR VPWR _0652_ sky130_fd_sc_hd__inv_2
X_5913_ clknet_leaf_0_clk _0148_ VGND VGND VPWR VPWR reg_file.memory\[5\]\[7\] sky130_fd_sc_hd__dfxtp_1
X_5775_ clk_div.slow_clk _0058_ VGND VGND VPWR VPWR seven_seg_conv.temp\[11\] sky130_fd_sc_hd__dfxtp_1
X_5844_ clknet_leaf_18_clk _0094_ VGND VGND VPWR VPWR reg_file.memory\[9\]\[18\] sky130_fd_sc_hd__dfxtp_1
XFILLER_0_90_159 VGND VGND VPWR VPWR sky130_fd_sc_hd__fill_1
X_4726_ clk_div.counter\[11\] clk_div.counter\[10\] _2319_ VGND VGND VPWR VPWR _2321_
+ sky130_fd_sc_hd__and3_1
X_4657_ _2271_ _1242_ _2261_ VGND VGND VPWR VPWR _2273_ sky130_fd_sc_hd__or3_1
X_4588_ _2060_ _2128_ VGND VGND VPWR VPWR _2210_ sky130_fd_sc_hd__nor2_1
X_3608_ _0919_ _1211_ VGND VGND VPWR VPWR _1273_ sky130_fd_sc_hd__or2b_1
XFILLER_0_3_161 VGND VGND VPWR VPWR sky130_fd_sc_hd__fill_2
XFILLER_0_16_289 VGND VGND VPWR VPWR sky130_fd_sc_hd__fill_2
X_6258_ clknet_leaf_6_clk _0493_ VGND VGND VPWR VPWR ctrl_unit.PCWrite sky130_fd_sc_hd__dfxtp_1
XFILLER_0_58_90 VGND VGND VPWR VPWR sky130_fd_sc_hd__fill_1
X_6189_ clknet_leaf_13_clk _0424_ VGND VGND VPWR VPWR reg_file.memory\[21\]\[27\]
+ sky130_fd_sc_hd__dfxtp_1
X_3539_ _0998_ _1201_ _1203_ VGND VGND VPWR VPWR _1204_ sky130_fd_sc_hd__a21o_1
X_5209_ _2585_ VGND VGND VPWR VPWR _2597_ sky130_fd_sc_hd__clkbuf_4
XTAP_TAPCELL_ROW_67_593 VGND VPWR sky130_fd_sc_hd__tapvpwrvgnd_1
XPHY_EDGE_ROW_17_Left_108 VGND VGND VPWR VPWR sky130_fd_sc_hd__decap_3
XFILLER_0_81_137 VGND VGND VPWR VPWR sky130_fd_sc_hd__decap_3
XFILLER_0_62_351 VGND VGND VPWR VPWR sky130_fd_sc_hd__fill_1
XTAP_TAPCELL_ROW_50_493 VGND VPWR sky130_fd_sc_hd__tapvpwrvgnd_1
XPHY_EDGE_ROW_26_Left_117 VGND VGND VPWR VPWR sky130_fd_sc_hd__decap_3
XFILLER_0_89_215 VGND VGND VPWR VPWR sky130_fd_sc_hd__fill_1
XFILLER_0_54_59 VPWR VGND VPWR VGND sky130_ef_sc_hd__decap_12
XFILLER_0_54_26 VGND VGND VPWR VPWR sky130_fd_sc_hd__fill_2
XFILLER_0_70_58 VGND VGND VPWR VPWR sky130_fd_sc_hd__decap_4
XFILLER_0_57_156 VPWR VGND VPWR VGND sky130_ef_sc_hd__decap_12
X_2910_ _0574_ VGND VGND VPWR VPWR _0575_ sky130_fd_sc_hd__buf_2
XFILLER_0_45_307 VGND VGND VPWR VPWR sky130_fd_sc_hd__fill_1
XPHY_EDGE_ROW_35_Left_126 VGND VGND VPWR VPWR sky130_fd_sc_hd__decap_3
X_3890_ _1542_ _1360_ _1536_ VGND VGND VPWR VPWR _1546_ sky130_fd_sc_hd__and3b_1
X_4442_ _1658_ _1945_ _1948_ _1708_ VGND VGND VPWR VPWR _2076_ sky130_fd_sc_hd__o22ai_2
XFILLER_0_80_170 VGND VGND VPWR VPWR sky130_fd_sc_hd__decap_6
X_4511_ _1831_ _2135_ _2139_ _1869_ _2001_ VGND VGND VPWR VPWR _2140_ sky130_fd_sc_hd__o32a_1
XPHY_EDGE_ROW_44_Left_135 VGND VGND VPWR VPWR sky130_fd_sc_hd__decap_3
X_5560_ _2446_ reg_file.memory\[21\]\[18\] _2771_ VGND VGND VPWR VPWR _2780_ sky130_fd_sc_hd__mux2_1
X_5491_ _2743_ VGND VGND VPWR VPWR _0382_ sky130_fd_sc_hd__clkbuf_1
X_4373_ _1768_ _1932_ _2011_ _1845_ VGND VGND VPWR VPWR _2012_ sky130_fd_sc_hd__o211a_1
X_3324_ reg_file.memory\[15\]\[10\] _0552_ _0616_ _0988_ VGND VGND VPWR VPWR _0989_
+ sky130_fd_sc_hd__a211o_1
X_6112_ clknet_leaf_21_clk _0347_ VGND VGND VPWR VPWR reg_file.memory\[15\]\[14\]
+ sky130_fd_sc_hd__dfxtp_1
XFILLER_0_0_153 VGND VGND VPWR VPWR sky130_fd_sc_hd__fill_1
XFILLER_0_0_186 VGND VGND VPWR VPWR sky130_fd_sc_hd__decap_4
X_6043_ clknet_leaf_26_clk _0278_ VGND VGND VPWR VPWR reg_file.memory\[0\]\[9\] sky130_fd_sc_hd__dfxtp_1
X_3255_ reg_file.memory\[7\]\[14\] _0674_ _0599_ reg_file.memory\[2\]\[14\] _0580_
+ VGND VGND VPWR VPWR _0920_ sky130_fd_sc_hd__o221a_1
XTAP_TAPCELL_ROW_64_574 VGND VPWR sky130_fd_sc_hd__tapvpwrvgnd_1
XPHY_EDGE_ROW_53_Left_144 VGND VGND VPWR VPWR sky130_fd_sc_hd__decap_3
X_3186_ _0850_ reg_file.memory\[10\]\[19\] _0648_ VGND VGND VPWR VPWR _0851_ sky130_fd_sc_hd__mux2_1
X_4709_ _2302_ _2309_ _2310_ VGND VGND VPWR VPWR _2311_ sky130_fd_sc_hd__and3_1
X_5758_ clknet_leaf_6_clk _0042_ VGND VGND VPWR VPWR clk_div.counter\[13\] sky130_fd_sc_hd__dfxtp_1
XFILLER_0_63_159 VGND VGND VPWR VPWR sky130_fd_sc_hd__decap_8
XFILLER_0_63_137 VGND VGND VPWR VPWR sky130_fd_sc_hd__decap_8
XPHY_EDGE_ROW_62_Left_153 VGND VGND VPWR VPWR sky130_fd_sc_hd__decap_3
X_5827_ clknet_leaf_27_clk _0077_ VGND VGND VPWR VPWR reg_file.memory\[9\]\[1\] sky130_fd_sc_hd__dfxtp_1
X_5689_ _2847_ VGND VGND VPWR VPWR _0476_ sky130_fd_sc_hd__clkbuf_1
XPHY_EDGE_ROW_71_Left_162 VGND VGND VPWR VPWR sky130_fd_sc_hd__decap_3
XFILLER_0_54_104 VGND VGND VPWR VPWR sky130_fd_sc_hd__decap_8
XFILLER_0_39_167 VGND VGND VPWR VPWR sky130_fd_sc_hd__fill_1
XFILLER_0_39_101 VGND VGND VPWR VPWR sky130_fd_sc_hd__fill_2
XPHY_EDGE_ROW_80_Left_171 VGND VGND VPWR VPWR sky130_fd_sc_hd__decap_3
XFILLER_0_54_148 VGND VGND VPWR VPWR sky130_fd_sc_hd__decap_4
XFILLER_0_49_26 VGND VGND VPWR VPWR sky130_fd_sc_hd__fill_1
X_3040_ reg_file.memory\[25\]\[28\] _0704_ _0671_ VGND VGND VPWR VPWR _0705_ sky130_fd_sc_hd__mux2_1
XFILLER_0_81_57 VPWR VGND VPWR VGND sky130_ef_sc_hd__decap_12
XFILLER_0_81_24 VGND VGND VPWR VPWR sky130_fd_sc_hd__decap_3
XFILLER_0_65_69 VGND VGND VPWR VPWR sky130_fd_sc_hd__decap_4
X_4991_ _2480_ VGND VGND VPWR VPWR _0145_ sky130_fd_sc_hd__clkbuf_1
XTAP_TAPCELL_ROW_61_555 VGND VPWR sky130_fd_sc_hd__tapvpwrvgnd_1
XFILLER_0_45_126 VGND VGND VPWR VPWR sky130_fd_sc_hd__decap_8
X_5543_ _2759_ VGND VGND VPWR VPWR _2771_ sky130_fd_sc_hd__clkbuf_4
X_5612_ _2796_ VGND VGND VPWR VPWR _2808_ sky130_fd_sc_hd__clkbuf_4
X_3873_ _1522_ _1527_ _1528_ VGND VGND VPWR VPWR _1529_ sky130_fd_sc_hd__or3b_1
X_3942_ _1355_ _1589_ _1592_ _1596_ _1597_ VGND VGND VPWR VPWR _1598_ sky130_fd_sc_hd__a311o_1
XTAP_TAPCELL_ROW_18_298 VGND VPWR sky130_fd_sc_hd__tapvpwrvgnd_1
X_4425_ _2020_ VGND VGND VPWR VPWR _2060_ sky130_fd_sc_hd__buf_2
X_4356_ _1056_ _1063_ VGND VGND VPWR VPWR _1995_ sky130_fd_sc_hd__and2b_1
XFILLER_0_5_289 VGND VGND VPWR VPWR sky130_fd_sc_hd__fill_1
X_5474_ reg_file.memory\[1\]\[9\] VGND VGND VPWR VPWR _2735_ sky130_fd_sc_hd__clkbuf_1
X_4287_ _1832_ _1833_ VGND VGND VPWR VPWR _1930_ sky130_fd_sc_hd__nand2_1
X_6026_ clknet_leaf_12_clk _0261_ VGND VGND VPWR VPWR reg_file.memory\[8\]\[24\] sky130_fd_sc_hd__dfxtp_1
X_3238_ _0901_ _0902_ VGND VGND VPWR VPWR _0903_ sky130_fd_sc_hd__nand2_1
X_3307_ _0967_ _0971_ _0610_ VGND VGND VPWR VPWR _0972_ sky130_fd_sc_hd__o21a_1
X_3169_ reg_file.memory\[8\]\[20\] reg_file.memory\[9\]\[20\] _0639_ VGND VGND VPWR
+ VPWR _0834_ sky130_fd_sc_hd__mux2_1
XFILLER_0_68_218 VGND VGND VPWR VPWR sky130_fd_sc_hd__decap_8
XTAP_TAPCELL_ROW_52_500 VGND VPWR sky130_fd_sc_hd__tapvpwrvgnd_1
XTAP_TAPCELL_ROW_1_199 VGND VPWR sky130_fd_sc_hd__tapvpwrvgnd_1
XFILLER_0_3_3 VGND VGND VPWR VPWR sky130_fd_sc_hd__decap_6
XTAP_TAPCELL_ROW_9_244 VGND VPWR sky130_fd_sc_hd__tapvpwrvgnd_1
XTAP_TAPCELL_ROW_83_691 VGND VPWR sky130_fd_sc_hd__tapvpwrvgnd_1
XFILLER_0_51_27 VGND VGND VPWR VPWR sky130_fd_sc_hd__fill_1
XTAP_TAPCELL_ROW_15_279 VGND VPWR sky130_fd_sc_hd__tapvpwrvgnd_1
X_4210_ _1675_ _1757_ VGND VGND VPWR VPWR _1855_ sky130_fd_sc_hd__nand2_1
Xclkload25 clknet_leaf_13_clk VGND VGND VPWR VPWR clkload25/Y sky130_fd_sc_hd__inv_6
XFILLER_0_50_195 VGND VGND VPWR VPWR sky130_fd_sc_hd__fill_1
Xclkload14 clknet_leaf_26_clk VGND VGND VPWR VPWR clkload14/Y sky130_fd_sc_hd__clkinv_4
X_3023_ _0685_ _0687_ _0665_ VGND VGND VPWR VPWR _0688_ sky130_fd_sc_hd__mux2_1
X_4072_ _1715_ _1717_ VGND VGND VPWR VPWR _1718_ sky130_fd_sc_hd__nand2_1
X_4141_ _1152_ _1670_ VGND VGND VPWR VPWR _1787_ sky130_fd_sc_hd__nand2_1
X_5190_ _2587_ VGND VGND VPWR VPWR _0237_ sky130_fd_sc_hd__clkbuf_1
X_4974_ _2470_ VGND VGND VPWR VPWR _0138_ sky130_fd_sc_hd__clkbuf_1
X_3925_ _1574_ _1577_ _1569_ VGND VGND VPWR VPWR _1581_ sky130_fd_sc_hd__a21oi_1
XFILLER_0_81_3 VGND VGND VPWR VPWR sky130_fd_sc_hd__decap_6
X_5526_ _2762_ VGND VGND VPWR VPWR _0398_ sky130_fd_sc_hd__clkbuf_1
X_3856_ _1509_ _1506_ _1504_ VGND VGND VPWR VPWR _1512_ sky130_fd_sc_hd__a21bo_1
Xclkload8 clknet_leaf_20_clk VGND VGND VPWR VPWR clkload8/Y sky130_fd_sc_hd__clkinv_4
X_3787_ _1426_ _1442_ _1436_ _1434_ VGND VGND VPWR VPWR _1443_ sky130_fd_sc_hd__a2bb2o_1
X_5388_ _2402_ _2404_ _2689_ VGND VGND VPWR VPWR _2690_ sky130_fd_sc_hd__or3_4
X_5457_ _2726_ VGND VGND VPWR VPWR _0365_ sky130_fd_sc_hd__clkbuf_1
X_4339_ _1188_ _1978_ VGND VGND VPWR VPWR _1979_ sky130_fd_sc_hd__xnor2_1
X_4408_ _2043_ _2031_ _1200_ VGND VGND VPWR VPWR _2044_ sky130_fd_sc_hd__o21a_1
XTAP_TAPCELL_ROW_6_225 VGND VPWR sky130_fd_sc_hd__tapvpwrvgnd_1
X_6009_ clknet_leaf_26_clk _0244_ VGND VGND VPWR VPWR reg_file.memory\[8\]\[7\] sky130_fd_sc_hd__dfxtp_1
XTAP_TAPCELL_ROW_80_672 VGND VPWR sky130_fd_sc_hd__tapvpwrvgnd_1
XFILLER_0_64_265 VGND VGND VPWR VPWR sky130_fd_sc_hd__fill_2
XFILLER_0_20_346 VGND VGND VPWR VPWR sky130_fd_sc_hd__fill_1
XTAP_TAPCELL_ROW_28_360 VGND VPWR sky130_fd_sc_hd__tapvpwrvgnd_1
X_4690_ net2 VGND VGND VPWR VPWR _0028_ sky130_fd_sc_hd__inv_2
X_3572_ _0706_ _1236_ VGND VGND VPWR VPWR _1237_ sky130_fd_sc_hd__and2_1
XFILLER_0_55_232 VGND VGND VPWR VPWR sky130_fd_sc_hd__decap_4
XFILLER_0_55_221 VGND VGND VPWR VPWR sky130_fd_sc_hd__decap_3
X_3641_ _0885_ _1216_ _1217_ VGND VGND VPWR VPWR _1306_ sky130_fd_sc_hd__nor3_1
X_3710_ _1365_ VGND VGND VPWR VPWR _1366_ sky130_fd_sc_hd__inv_2
XFILLER_0_11_52 VGND VGND VPWR VPWR sky130_fd_sc_hd__decap_4
X_5311_ reg_file.memory\[0\]\[28\] VGND VGND VPWR VPWR _2649_ sky130_fd_sc_hd__clkbuf_1
XFILLER_0_87_89 VGND VGND VPWR VPWR sky130_fd_sc_hd__fill_1
X_5242_ _2614_ VGND VGND VPWR VPWR _0262_ sky130_fd_sc_hd__clkbuf_1
X_5173_ _2463_ reg_file.memory\[7\]\[26\] _2570_ VGND VGND VPWR VPWR _2577_ sky130_fd_sc_hd__mux2_1
XTAP_TAPCELL_ROW_86_709 VGND VPWR sky130_fd_sc_hd__tapvpwrvgnd_1
X_4124_ _1165_ _1769_ VGND VGND VPWR VPWR _1770_ sky130_fd_sc_hd__nor2_1
X_4055_ _1145_ VGND VGND VPWR VPWR _1701_ sky130_fd_sc_hd__clkbuf_4
X_3006_ _0670_ VGND VGND VPWR VPWR _0671_ sky130_fd_sc_hd__clkbuf_4
Xinput1 next VGND VGND VPWR VPWR net1 sky130_fd_sc_hd__dlymetal6s2s_1
XTAP_TAPCELL_ROW_3_206 VGND VPWR sky130_fd_sc_hd__tapvpwrvgnd_1
X_4888_ _2412_ VGND VGND VPWR VPWR _0110_ sky130_fd_sc_hd__clkbuf_1
X_4957_ alu.ALUResult\[24\] VGND VGND VPWR VPWR _2459_ sky130_fd_sc_hd__dlymetal6s2s_1
XTAP_TAPCELL_ROW_34_396 VGND VPWR sky130_fd_sc_hd__tapvpwrvgnd_1
X_3908_ _1563_ _1558_ VGND VGND VPWR VPWR _1564_ sky130_fd_sc_hd__nor2_1
X_5509_ _2752_ VGND VGND VPWR VPWR _0391_ sky130_fd_sc_hd__clkbuf_1
X_3839_ _1482_ _1483_ _1488_ VGND VGND VPWR VPWR _1495_ sky130_fd_sc_hd__o21bai_1
XFILLER_0_6_362 VGND VGND VPWR VPWR sky130_fd_sc_hd__fill_2
XFILLER_0_69_346 VGND VGND VPWR VPWR sky130_fd_sc_hd__fill_1
XFILLER_0_69_335 VGND VGND VPWR VPWR sky130_fd_sc_hd__fill_1
XTAP_TAPCELL_ROW_25_341 VGND VPWR sky130_fd_sc_hd__tapvpwrvgnd_1
XTAP_TAPCELL_ROW_48_477 VGND VPWR sky130_fd_sc_hd__tapvpwrvgnd_1
X_4742_ _2330_ _2331_ VGND VGND VPWR VPWR _2332_ sky130_fd_sc_hd__and2_1
XFILLER_0_87_176 VGND VGND VPWR VPWR sky130_fd_sc_hd__fill_2
X_5791_ clk_div.slow_clk _0074_ VGND VGND VPWR VPWR seven_seg_conv.temp\[27\] sky130_fd_sc_hd__dfxtp_1
X_5860_ clk_div.slow_clk _0002_ VGND VGND VPWR VPWR net13 sky130_fd_sc_hd__dfxtp_1
X_4811_ _2369_ VGND VGND VPWR VPWR _0076_ sky130_fd_sc_hd__clkbuf_1
X_4673_ _2071_ _2202_ VGND VGND VPWR VPWR _2288_ sky130_fd_sc_hd__nor2_1
X_3624_ _1082_ _1184_ VGND VGND VPWR VPWR _1289_ sky130_fd_sc_hd__or2_1
X_3555_ _0846_ _0853_ VGND VGND VPWR VPWR _1220_ sky130_fd_sc_hd__nor2_1
XTAP_TAPCELL_ROW_31_377 VGND VPWR sky130_fd_sc_hd__tapvpwrvgnd_1
X_3486_ _1148_ _1150_ _0662_ VGND VGND VPWR VPWR _1151_ sky130_fd_sc_hd__mux2_1
X_5225_ _2605_ VGND VGND VPWR VPWR _0254_ sky130_fd_sc_hd__clkbuf_1
X_5156_ _2446_ reg_file.memory\[7\]\[18\] _2559_ VGND VGND VPWR VPWR _2568_ sky130_fd_sc_hd__mux2_1
XFILLER_0_78_165 VGND VGND VPWR VPWR sky130_fd_sc_hd__fill_2
X_4038_ _1682_ _1683_ VGND VGND VPWR VPWR _1684_ sky130_fd_sc_hd__nand2_1
X_4107_ _1710_ _1752_ VGND VGND VPWR VPWR _1753_ sky130_fd_sc_hd__nand2_1
XTAP_TAPCELL_ROW_39_422 VGND VPWR sky130_fd_sc_hd__tapvpwrvgnd_1
X_5087_ _2531_ VGND VGND VPWR VPWR _0190_ sky130_fd_sc_hd__clkbuf_1
XFILLER_0_34_213 VGND VGND VPWR VPWR sky130_fd_sc_hd__fill_1
XTAP_TAPCELL_ROW_22_322 VGND VPWR sky130_fd_sc_hd__tapvpwrvgnd_1
X_5989_ clknet_leaf_17_clk _0224_ VGND VGND VPWR VPWR reg_file.memory\[7\]\[19\] sky130_fd_sc_hd__dfxtp_1
XFILLER_0_6_192 VGND VGND VPWR VPWR sky130_fd_sc_hd__decap_4
XTAP_TAPCELL_ROW_45_458 VGND VPWR sky130_fd_sc_hd__tapvpwrvgnd_1
XFILLER_0_80_363 VGND VGND VPWR VPWR sky130_fd_sc_hd__fill_1
XFILLER_0_40_227 VGND VGND VPWR VPWR sky130_fd_sc_hd__fill_1
X_3340_ reg_file.memory\[15\]\[9\] _0552_ _0616_ _1004_ VGND VGND VPWR VPWR _1005_
+ sky130_fd_sc_hd__a211o_1
X_3271_ reg_file.memory\[2\]\[13\] _0566_ _0572_ reg_file.memory\[7\]\[13\] _0580_
+ VGND VGND VPWR VPWR _0936_ sky130_fd_sc_hd__o221a_1
X_5010_ _2490_ VGND VGND VPWR VPWR _0154_ sky130_fd_sc_hd__clkbuf_1
XFILLER_0_84_79 VGND VGND VPWR VPWR sky130_fd_sc_hd__decap_4
X_5912_ clknet_leaf_0_clk _0147_ VGND VGND VPWR VPWR reg_file.memory\[5\]\[6\] sky130_fd_sc_hd__dfxtp_1
XFILLER_0_90_116 VPWR VGND VPWR VGND sky130_ef_sc_hd__decap_12
X_4725_ clk_div.counter\[10\] _2319_ VGND VGND VPWR VPWR _0039_ sky130_fd_sc_hd__xor2_1
X_2986_ reg_file.memory\[5\]\[30\] _0642_ _0650_ VGND VGND VPWR VPWR _0651_ sky130_fd_sc_hd__mux2_1
X_5774_ clk_div.slow_clk _0057_ VGND VGND VPWR VPWR seven_seg_conv.temp\[10\] sky130_fd_sc_hd__dfxtp_1
X_5843_ clknet_leaf_18_clk _0093_ VGND VGND VPWR VPWR reg_file.memory\[9\]\[17\] sky130_fd_sc_hd__dfxtp_1
XFILLER_0_71_363 VGND VGND VPWR VPWR sky130_fd_sc_hd__fill_1
X_4656_ _2271_ _2261_ _1242_ VGND VGND VPWR VPWR _2272_ sky130_fd_sc_hd__o21a_1
X_4587_ _2207_ _2208_ _1999_ VGND VGND VPWR VPWR _2209_ sky130_fd_sc_hd__and3b_1
X_3538_ _0982_ _1202_ VGND VGND VPWR VPWR _1203_ sky130_fd_sc_hd__nand2_1
X_3607_ _0903_ _1212_ VGND VGND VPWR VPWR _1272_ sky130_fd_sc_hd__xor2_1
X_6257_ clknet_leaf_13_clk _0492_ VGND VGND VPWR VPWR reg_file.memory\[2\]\[31\] sky130_fd_sc_hd__dfxtp_1
X_6188_ clknet_leaf_15_clk _0423_ VGND VGND VPWR VPWR reg_file.memory\[21\]\[26\]
+ sky130_fd_sc_hd__dfxtp_1
X_5139_ _2547_ VGND VGND VPWR VPWR _2559_ sky130_fd_sc_hd__clkbuf_4
X_3469_ _1133_ reg_file.memory\[10\]\[2\] _0644_ VGND VGND VPWR VPWR _1134_ sky130_fd_sc_hd__mux2_1
X_5208_ _2596_ VGND VGND VPWR VPWR _0246_ sky130_fd_sc_hd__clkbuf_1
XTAP_TAPCELL_ROW_67_594 VGND VPWR sky130_fd_sc_hd__tapvpwrvgnd_1
XFILLER_0_57_102 VGND VGND VPWR VPWR sky130_fd_sc_hd__decap_8
XFILLER_0_70_37 VGND VGND VPWR VPWR sky130_fd_sc_hd__decap_4
XFILLER_0_70_15 VPWR VGND VPWR VGND sky130_ef_sc_hd__decap_12
XFILLER_0_57_146 VGND VGND VPWR VPWR sky130_fd_sc_hd__fill_2
XFILLER_0_57_113 VGND VGND VPWR VPWR sky130_fd_sc_hd__decap_4
XFILLER_0_53_330 VGND VGND VPWR VPWR sky130_fd_sc_hd__fill_1
XFILLER_0_79_79 VGND VGND VPWR VPWR sky130_fd_sc_hd__decap_8
X_4372_ _1816_ _1922_ VGND VGND VPWR VPWR _2011_ sky130_fd_sc_hd__nand2_1
X_4441_ _1943_ _2071_ _2074_ _2064_ VGND VGND VPWR VPWR _2075_ sky130_fd_sc_hd__o22ai_1
X_4510_ _2071_ _2037_ _2138_ _2064_ VGND VGND VPWR VPWR _2139_ sky130_fd_sc_hd__o22ai_1
XFILLER_0_53_363 VGND VGND VPWR VPWR sky130_fd_sc_hd__fill_1
X_6111_ clknet_leaf_22_clk _0346_ VGND VGND VPWR VPWR reg_file.memory\[15\]\[13\]
+ sky130_fd_sc_hd__dfxtp_1
XPHY_EDGE_ROW_9_Right_9 VGND VGND VPWR VPWR sky130_fd_sc_hd__decap_3
X_5490_ reg_file.memory\[1\]\[17\] VGND VGND VPWR VPWR _2743_ sky130_fd_sc_hd__clkbuf_1
X_3254_ _0911_ _0918_ VGND VGND VPWR VPWR _0919_ sky130_fd_sc_hd__nor2_1
X_3323_ _0983_ _0987_ _0610_ VGND VGND VPWR VPWR _0988_ sky130_fd_sc_hd__o21a_1
XFILLER_0_28_94 VGND VGND VPWR VPWR sky130_fd_sc_hd__fill_1
X_3185_ reg_file.memory\[8\]\[19\] reg_file.memory\[9\]\[19\] _0639_ VGND VGND VPWR
+ VPWR _0850_ sky130_fd_sc_hd__mux2_1
X_6042_ clknet_leaf_26_clk _0277_ VGND VGND VPWR VPWR reg_file.memory\[0\]\[8\] sky130_fd_sc_hd__dfxtp_1
XTAP_TAPCELL_ROW_64_575 VGND VPWR sky130_fd_sc_hd__tapvpwrvgnd_1
X_4708_ clk_div.counter\[3\] _2304_ clk_div.counter\[4\] VGND VGND VPWR VPWR _2310_
+ sky130_fd_sc_hd__a21o_1
X_5757_ clknet_leaf_6_clk _0041_ VGND VGND VPWR VPWR clk_div.counter\[12\] sky130_fd_sc_hd__dfxtp_1
X_2969_ _0629_ _0630_ _0633_ VGND VGND VPWR VPWR _0634_ sky130_fd_sc_hd__and3_1
XFILLER_0_63_149 VGND VGND VPWR VPWR sky130_fd_sc_hd__decap_6
XFILLER_0_44_363 VGND VGND VPWR VPWR sky130_fd_sc_hd__fill_1
X_5826_ clknet_leaf_27_clk _0076_ VGND VGND VPWR VPWR reg_file.memory\[9\]\[0\] sky130_fd_sc_hd__dfxtp_1
X_5688_ reg_file.memory\[2\]\[15\] VGND VGND VPWR VPWR _2847_ sky130_fd_sc_hd__clkbuf_1
X_4639_ _2255_ _2239_ _2256_ VGND VGND VPWR VPWR _2257_ sky130_fd_sc_hd__a21oi_1
XTAP_TAPCELL_ROW_55_520 VGND VPWR sky130_fd_sc_hd__tapvpwrvgnd_1
XFILLER_0_39_146 VGND VGND VPWR VPWR sky130_fd_sc_hd__fill_2
XFILLER_0_40_29 VGND VGND VPWR VPWR sky130_fd_sc_hd__fill_2
XFILLER_0_27_319 VGND VGND VPWR VPWR sky130_fd_sc_hd__fill_1
XTAP_TAPCELL_ROW_78_656 VGND VPWR sky130_fd_sc_hd__tapvpwrvgnd_1
XFILLER_0_4_29 VGND VGND VPWR VPWR sky130_fd_sc_hd__fill_1
XFILLER_0_81_69 VGND VGND VPWR VPWR sky130_fd_sc_hd__decap_6
X_4990_ _2417_ reg_file.memory\[5\]\[4\] _2475_ VGND VGND VPWR VPWR _2480_ sky130_fd_sc_hd__mux2_1
XFILLER_0_14_41 VGND VGND VPWR VPWR sky130_fd_sc_hd__decap_4
X_3941_ alu.ALUResult\[3\] seven_seg_conv.temp\[3\] _1352_ VGND VGND VPWR VPWR _1597_
+ sky130_fd_sc_hd__mux2_1
XTAP_TAPCELL_ROW_18_299 VGND VPWR sky130_fd_sc_hd__tapvpwrvgnd_1
XTAP_TAPCELL_ROW_61_556 VGND VPWR sky130_fd_sc_hd__tapvpwrvgnd_1
XFILLER_0_45_138 VGND VGND VPWR VPWR sky130_fd_sc_hd__decap_6
X_5542_ _2770_ VGND VGND VPWR VPWR _0406_ sky130_fd_sc_hd__clkbuf_1
X_5611_ _2807_ VGND VGND VPWR VPWR _0438_ sky130_fd_sc_hd__clkbuf_1
XFILLER_0_30_73 VGND VGND VPWR VPWR sky130_fd_sc_hd__fill_2
X_3872_ _1517_ _1519_ VGND VGND VPWR VPWR _1528_ sky130_fd_sc_hd__and2_1
XFILLER_0_5_279 VGND VGND VPWR VPWR sky130_fd_sc_hd__fill_1
X_4424_ _1900_ VGND VGND VPWR VPWR _2059_ sky130_fd_sc_hd__clkbuf_4
X_4355_ _1954_ VGND VGND VPWR VPWR _1994_ sky130_fd_sc_hd__buf_2
X_5473_ _2734_ VGND VGND VPWR VPWR _0373_ sky130_fd_sc_hd__clkbuf_1
X_3306_ _0572_ _0968_ _0970_ _0605_ VGND VGND VPWR VPWR _0971_ sky130_fd_sc_hd__o211a_1
X_6025_ clknet_leaf_10_clk _0260_ VGND VGND VPWR VPWR reg_file.memory\[8\]\[23\] sky130_fd_sc_hd__dfxtp_1
X_4286_ _1743_ _1928_ VGND VGND VPWR VPWR _1929_ sky130_fd_sc_hd__nor2_1
X_3237_ _0893_ _0900_ VGND VGND VPWR VPWR _0902_ sky130_fd_sc_hd__or2_1
X_3168_ reg_file.memory\[0\]\[20\] _0832_ _0655_ VGND VGND VPWR VPWR _0833_ sky130_fd_sc_hd__mux2_1
X_3099_ reg_file.memory\[21\]\[24\] _0546_ _0626_ _0763_ VGND VGND VPWR VPWR _0764_
+ sky130_fd_sc_hd__o211ai_4
XTAP_TAPCELL_ROW_52_501 VGND VPWR sky130_fd_sc_hd__tapvpwrvgnd_1
X_5809_ _0511_ _0014_ VGND VGND VPWR VPWR alu.ALUResult\[15\] sky130_fd_sc_hd__dlxtn_1
XTAP_TAPCELL_ROW_9_245 VGND VPWR sky130_fd_sc_hd__tapvpwrvgnd_1
XFILLER_0_82_233 VGND VGND VPWR VPWR sky130_fd_sc_hd__fill_1
Xclkload26 clknet_leaf_14_clk VGND VGND VPWR VPWR clkload26/Y sky130_fd_sc_hd__inv_12
Xclkload15 clknet_leaf_27_clk VGND VGND VPWR VPWR clkload15/Y sky130_fd_sc_hd__inv_8
X_4140_ _1154_ VGND VGND VPWR VPWR _1786_ sky130_fd_sc_hd__buf_2
XFILLER_0_23_355 VGND VGND VPWR VPWR sky130_fd_sc_hd__fill_2
X_3022_ _0686_ reg_file.memory\[10\]\[29\] _0650_ VGND VGND VPWR VPWR _0687_ sky130_fd_sc_hd__mux2_1
X_4071_ _1710_ _1716_ VGND VGND VPWR VPWR _1717_ sky130_fd_sc_hd__nand2_1
X_4973_ _2469_ reg_file.memory\[4\]\[29\] _2451_ VGND VGND VPWR VPWR _2470_ sky130_fd_sc_hd__mux2_1
XFILLER_0_25_73 VGND VGND VPWR VPWR sky130_fd_sc_hd__fill_1
X_3924_ _1575_ VGND VGND VPWR VPWR _1580_ sky130_fd_sc_hd__inv_2
XFILLER_0_74_3 VGND VGND VPWR VPWR sky130_fd_sc_hd__decap_4
X_5525_ _2411_ reg_file.memory\[21\]\[1\] _2760_ VGND VGND VPWR VPWR _2762_ sky130_fd_sc_hd__mux2_1
X_5456_ reg_file.memory\[1\]\[0\] VGND VGND VPWR VPWR _2726_ sky130_fd_sc_hd__clkbuf_1
X_3855_ _1502_ _1506_ _1498_ VGND VGND VPWR VPWR _1511_ sky130_fd_sc_hd__nor3b_1
X_3786_ _1438_ VGND VGND VPWR VPWR _1442_ sky130_fd_sc_hd__inv_2
Xclkload9 clknet_leaf_21_clk VGND VGND VPWR VPWR clkload9/Y sky130_fd_sc_hd__inv_6
X_4269_ _1803_ _1911_ _1154_ VGND VGND VPWR VPWR _1912_ sky130_fd_sc_hd__mux2_1
X_5387_ _2406_ _1342_ _1328_ VGND VGND VPWR VPWR _2689_ sky130_fd_sc_hd__or3b_1
X_4338_ _1080_ _1961_ _1081_ VGND VGND VPWR VPWR _1978_ sky130_fd_sc_hd__o21ba_1
X_4407_ _1006_ _1013_ VGND VGND VPWR VPWR _2043_ sky130_fd_sc_hd__and2b_1
XFILLER_0_1_271 VGND VGND VPWR VPWR sky130_fd_sc_hd__decap_4
XTAP_TAPCELL_ROW_6_226 VGND VPWR sky130_fd_sc_hd__tapvpwrvgnd_1
X_6008_ clknet_leaf_26_clk _0243_ VGND VGND VPWR VPWR reg_file.memory\[8\]\[6\] sky130_fd_sc_hd__dfxtp_1
XTAP_TAPCELL_ROW_80_673 VGND VPWR sky130_fd_sc_hd__tapvpwrvgnd_1
XFILLER_0_64_211 VPWR VGND VPWR VGND sky130_ef_sc_hd__decap_12
XFILLER_0_49_263 VGND VGND VPWR VPWR sky130_fd_sc_hd__decap_3
XFILLER_0_20_358 VGND VGND VPWR VPWR sky130_fd_sc_hd__fill_2
XFILLER_0_62_27 VGND VGND VPWR VPWR sky130_fd_sc_hd__fill_1
XFILLER_0_55_200 VGND VGND VPWR VPWR sky130_fd_sc_hd__decap_8
XTAP_TAPCELL_ROW_28_361 VGND VPWR sky130_fd_sc_hd__tapvpwrvgnd_1
XFILLER_0_70_236 VGND VGND VPWR VPWR sky130_fd_sc_hd__decap_3
X_3571_ _0698_ _0705_ VGND VGND VPWR VPWR _1236_ sky130_fd_sc_hd__or2_1
X_5310_ _2648_ VGND VGND VPWR VPWR _0296_ sky130_fd_sc_hd__clkbuf_1
X_3640_ _1216_ _1304_ VGND VGND VPWR VPWR _1305_ sky130_fd_sc_hd__nor2_1
XFILLER_0_15_108 VGND VGND VPWR VPWR sky130_fd_sc_hd__fill_1
XFILLER_0_23_163 VGND VGND VPWR VPWR sky130_fd_sc_hd__fill_2
XFILLER_0_87_57 VGND VGND VPWR VPWR sky130_fd_sc_hd__fill_1
X_5172_ _2576_ VGND VGND VPWR VPWR _0230_ sky130_fd_sc_hd__clkbuf_1
X_5241_ reg_file.memory\[8\]\[25\] alu.ALUResult\[25\] _2608_ VGND VGND VPWR VPWR
+ _2614_ sky130_fd_sc_hd__mux2_1
X_4123_ _1063_ _1670_ VGND VGND VPWR VPWR _1769_ sky130_fd_sc_hd__nand2_1
XTAP_TAPCELL_ROW_3_207 VGND VPWR sky130_fd_sc_hd__tapvpwrvgnd_1
Xinput2 rst VGND VGND VPWR VPWR net2 sky130_fd_sc_hd__clkbuf_2
XFILLER_0_78_347 VGND VGND VPWR VPWR sky130_fd_sc_hd__fill_1
X_4054_ _1696_ _1699_ VGND VGND VPWR VPWR _1700_ sky130_fd_sc_hd__nand2_1
X_3005_ _0669_ VGND VGND VPWR VPWR _0670_ sky130_fd_sc_hd__clkbuf_4
X_4956_ _2458_ VGND VGND VPWR VPWR _0132_ sky130_fd_sc_hd__clkbuf_1
X_4887_ _2411_ reg_file.memory\[4\]\[1\] _2409_ VGND VGND VPWR VPWR _2412_ sky130_fd_sc_hd__mux2_1
XFILLER_0_52_82 VGND VGND VPWR VPWR sky130_fd_sc_hd__fill_2
XFILLER_0_46_200 VPWR VGND VPWR VGND sky130_ef_sc_hd__decap_12
XTAP_TAPCELL_ROW_34_397 VGND VPWR sky130_fd_sc_hd__tapvpwrvgnd_1
X_3838_ _1484_ _1486_ VGND VGND VPWR VPWR _1494_ sky130_fd_sc_hd__and2_1
X_3907_ _1551_ _1552_ VGND VGND VPWR VPWR _1563_ sky130_fd_sc_hd__nor2_1
X_5439_ _2717_ VGND VGND VPWR VPWR _0356_ sky130_fd_sc_hd__clkbuf_1
X_5508_ reg_file.memory\[1\]\[26\] VGND VGND VPWR VPWR _2752_ sky130_fd_sc_hd__clkbuf_1
X_3769_ _1409_ _1416_ _1424_ _1420_ VGND VGND VPWR VPWR _1425_ sky130_fd_sc_hd__a2bb2o_1
XTAP_TAPCELL_ROW_25_342 VGND VPWR sky130_fd_sc_hd__tapvpwrvgnd_1
XFILLER_0_87_122 VGND VGND VPWR VPWR sky130_fd_sc_hd__fill_2
XTAP_TAPCELL_ROW_48_478 VGND VPWR sky130_fd_sc_hd__tapvpwrvgnd_1
XFILLER_0_87_166 VGND VGND VPWR VPWR sky130_fd_sc_hd__fill_2
X_4741_ clk_div.counter\[16\] _2328_ VGND VGND VPWR VPWR _2331_ sky130_fd_sc_hd__or2_1
X_4672_ _1915_ _2284_ _2285_ _2286_ VGND VGND VPWR VPWR _2287_ sky130_fd_sc_hd__o31a_1
XFILLER_0_43_225 VPWR VGND VPWR VGND sky130_ef_sc_hd__decap_12
X_5790_ clk_div.slow_clk _0073_ VGND VGND VPWR VPWR seven_seg_conv.temp\[26\] sky130_fd_sc_hd__dfxtp_1
X_4810_ reg_file.memory\[9\]\[0\] VGND VGND VPWR VPWR _2369_ sky130_fd_sc_hd__clkbuf_1
X_3623_ _1287_ _1191_ VGND VGND VPWR VPWR _1288_ sky130_fd_sc_hd__xnor2_1
X_3554_ _0862_ _0869_ _1218_ VGND VGND VPWR VPWR _1219_ sky130_fd_sc_hd__a21oi_1
XTAP_TAPCELL_ROW_31_378 VGND VPWR sky130_fd_sc_hd__tapvpwrvgnd_1
X_3485_ _1149_ reg_file.memory\[10\]\[1\] _0644_ VGND VGND VPWR VPWR _1150_ sky130_fd_sc_hd__mux2_1
X_4106_ _0966_ _1670_ VGND VGND VPWR VPWR _1752_ sky130_fd_sc_hd__nand2_1
XTAP_TAPCELL_ROW_39_423 VGND VPWR sky130_fd_sc_hd__tapvpwrvgnd_1
XFILLER_0_37_3 VGND VGND VPWR VPWR sky130_fd_sc_hd__fill_1
X_5224_ reg_file.memory\[8\]\[17\] alu.ALUResult\[17\] _2597_ VGND VGND VPWR VPWR
+ _2605_ sky130_fd_sc_hd__mux2_1
XFILLER_0_11_188 VGND VGND VPWR VPWR sky130_fd_sc_hd__fill_2
XFILLER_0_11_199 VGND VGND VPWR VPWR sky130_fd_sc_hd__decap_3
X_5086_ _2444_ reg_file.memory\[6\]\[17\] _2523_ VGND VGND VPWR VPWR _2531_ sky130_fd_sc_hd__mux2_1
X_5155_ _2567_ VGND VGND VPWR VPWR _0222_ sky130_fd_sc_hd__clkbuf_1
X_4037_ _0837_ _1671_ VGND VGND VPWR VPWR _1683_ sky130_fd_sc_hd__nand2_1
X_5988_ clknet_leaf_18_clk _0223_ VGND VGND VPWR VPWR reg_file.memory\[7\]\[18\] sky130_fd_sc_hd__dfxtp_1
X_4939_ _2446_ reg_file.memory\[4\]\[18\] _2430_ VGND VGND VPWR VPWR _2447_ sky130_fd_sc_hd__mux2_1
XTAP_TAPCELL_ROW_22_323 VGND VPWR sky130_fd_sc_hd__tapvpwrvgnd_1
XFILLER_0_27_19 VGND VGND VPWR VPWR sky130_fd_sc_hd__fill_1
XPHY_EDGE_ROW_6_Left_97 VGND VGND VPWR VPWR sky130_fd_sc_hd__decap_3
XFILLER_0_84_158 VGND VGND VPWR VPWR sky130_fd_sc_hd__decap_8
XTAP_TAPCELL_ROW_45_459 VGND VPWR sky130_fd_sc_hd__tapvpwrvgnd_1
XFILLER_0_80_331 VGND VGND VPWR VPWR sky130_fd_sc_hd__fill_1
X_3270_ _0927_ _0934_ VGND VGND VPWR VPWR _0935_ sky130_fd_sc_hd__xnor2_2
XTAP_TAPCELL_ROW_36_404 VGND VPWR sky130_fd_sc_hd__tapvpwrvgnd_1
XFILLER_0_33_51 VGND VGND VPWR VPWR sky130_fd_sc_hd__fill_2
X_5842_ clknet_leaf_19_clk _0092_ VGND VGND VPWR VPWR reg_file.memory\[9\]\[16\] sky130_fd_sc_hd__dfxtp_1
X_5911_ clknet_leaf_0_clk _0146_ VGND VGND VPWR VPWR reg_file.memory\[5\]\[5\] sky130_fd_sc_hd__dfxtp_1
XFILLER_0_90_128 VPWR VGND VPWR VGND sky130_ef_sc_hd__decap_12
X_4724_ _2319_ _2320_ VGND VGND VPWR VPWR _0038_ sky130_fd_sc_hd__nor2_1
X_2985_ _0649_ VGND VGND VPWR VPWR _0650_ sky130_fd_sc_hd__clkbuf_4
XFILLER_0_75_169 VGND VGND VPWR VPWR sky130_fd_sc_hd__decap_8
XFILLER_0_71_353 VGND VGND VPWR VPWR sky130_fd_sc_hd__fill_1
X_4655_ _0682_ _0689_ VGND VGND VPWR VPWR _2271_ sky130_fd_sc_hd__and2b_1
X_5773_ clk_div.slow_clk _0056_ VGND VGND VPWR VPWR seven_seg_conv.temp\[9\] sky130_fd_sc_hd__dfxtp_1
X_6256_ clknet_leaf_11_clk _0491_ VGND VGND VPWR VPWR reg_file.memory\[2\]\[30\] sky130_fd_sc_hd__dfxtp_1
X_4586_ _0774_ _2198_ _2206_ VGND VGND VPWR VPWR _2208_ sky130_fd_sc_hd__or3_1
X_3606_ _0806_ _1224_ VGND VGND VPWR VPWR _1271_ sky130_fd_sc_hd__xor2_1
X_3537_ _0974_ _0981_ VGND VGND VPWR VPWR _1202_ sky130_fd_sc_hd__or2_1
X_3468_ reg_file.memory\[8\]\[2\] reg_file.memory\[9\]\[2\] _0635_ VGND VGND VPWR
+ VPWR _1133_ sky130_fd_sc_hd__mux2_1
X_6187_ clknet_leaf_8_clk _0422_ VGND VGND VPWR VPWR reg_file.memory\[21\]\[25\] sky130_fd_sc_hd__dfxtp_1
X_3399_ _1056_ _1063_ VGND VGND VPWR VPWR _1064_ sky130_fd_sc_hd__nand2_1
X_5138_ _2558_ VGND VGND VPWR VPWR _0214_ sky130_fd_sc_hd__clkbuf_1
X_5069_ _2427_ reg_file.memory\[6\]\[9\] _2512_ VGND VGND VPWR VPWR _2522_ sky130_fd_sc_hd__mux2_1
X_5207_ reg_file.memory\[8\]\[9\] alu.ALUResult\[9\] _2586_ VGND VGND VPWR VPWR _2596_
+ sky130_fd_sc_hd__mux2_1
XTAP_TAPCELL_ROW_67_595 VGND VPWR sky130_fd_sc_hd__tapvpwrvgnd_1
XFILLER_0_38_29 VGND VGND VPWR VPWR sky130_fd_sc_hd__fill_2
XFILLER_0_30_250 VGND VGND VPWR VPWR sky130_fd_sc_hd__fill_2
XTAP_TAPCELL_ROW_58_540 VGND VPWR sky130_fd_sc_hd__tapvpwrvgnd_1
XFILLER_0_70_27 VGND VGND VPWR VPWR sky130_fd_sc_hd__fill_1
XFILLER_0_57_169 VPWR VGND VPWR VGND sky130_ef_sc_hd__decap_12
X_4371_ _1708_ _2009_ VGND VGND VPWR VPWR _2010_ sky130_fd_sc_hd__nor2_1
X_4440_ _2023_ _2073_ _1789_ VGND VGND VPWR VPWR _2074_ sky130_fd_sc_hd__mux2_1
X_6110_ clknet_leaf_23_clk _0345_ VGND VGND VPWR VPWR reg_file.memory\[15\]\[12\]
+ sky130_fd_sc_hd__dfxtp_1
X_3322_ _0572_ _0984_ _0986_ _0605_ VGND VGND VPWR VPWR _0987_ sky130_fd_sc_hd__o211a_1
XFILLER_0_0_166 VGND VGND VPWR VPWR sky130_fd_sc_hd__fill_2
X_3253_ reg_file.memory\[25\]\[15\] _0917_ _0670_ VGND VGND VPWR VPWR _0918_ sky130_fd_sc_hd__mux2_2
X_3184_ reg_file.memory\[0\]\[19\] _0848_ _0655_ VGND VGND VPWR VPWR _0849_ sky130_fd_sc_hd__mux2_1
X_6041_ clknet_leaf_26_clk _0276_ VGND VGND VPWR VPWR reg_file.memory\[0\]\[7\] sky130_fd_sc_hd__dfxtp_1
XTAP_TAPCELL_ROW_64_576 VGND VPWR sky130_fd_sc_hd__tapvpwrvgnd_1
X_5825_ _0529_ _0014_ VGND VGND VPWR VPWR alu.ALUResult\[31\] sky130_fd_sc_hd__dlxtn_2
XFILLER_0_48_169 VGND VGND VPWR VPWR sky130_fd_sc_hd__decap_6
X_4707_ _2308_ VGND VGND VPWR VPWR _2309_ sky130_fd_sc_hd__inv_2
X_5756_ clknet_leaf_6_clk _0040_ VGND VGND VPWR VPWR clk_div.counter\[11\] sky130_fd_sc_hd__dfxtp_1
X_2899_ _0558_ _0555_ _0560_ _0563_ VGND VGND VPWR VPWR _0564_ sky130_fd_sc_hd__o211ai_2
X_2968_ PC\[4\] _0631_ _0632_ VGND VGND VPWR VPWR _0633_ sky130_fd_sc_hd__nand3_1
X_4638_ _0714_ _2254_ VGND VGND VPWR VPWR _2256_ sky130_fd_sc_hd__nor2_1
XFILLER_0_60_82 VGND VGND VPWR VPWR sky130_fd_sc_hd__fill_2
XFILLER_0_56_191 VGND VGND VPWR VPWR sky130_fd_sc_hd__decap_4
XFILLER_0_44_320 VGND VGND VPWR VPWR sky130_fd_sc_hd__fill_2
XFILLER_0_8_83 VGND VGND VPWR VPWR sky130_fd_sc_hd__fill_1
X_5687_ _2846_ VGND VGND VPWR VPWR _0475_ sky130_fd_sc_hd__clkbuf_1
X_4569_ _2151_ _2192_ _1704_ VGND VGND VPWR VPWR _2193_ sky130_fd_sc_hd__mux2_1
X_6239_ clknet_leaf_22_clk _0474_ VGND VGND VPWR VPWR reg_file.memory\[2\]\[13\] sky130_fd_sc_hd__dfxtp_1
XTAP_TAPCELL_ROW_55_521 VGND VPWR sky130_fd_sc_hd__tapvpwrvgnd_1
XFILLER_0_39_169 VGND VGND VPWR VPWR sky130_fd_sc_hd__fill_1
XTAP_TAPCELL_ROW_78_657 VGND VPWR sky130_fd_sc_hd__tapvpwrvgnd_1
XFILLER_0_85_264 VGND VGND VPWR VPWR sky130_fd_sc_hd__fill_2
XFILLER_0_81_48 VGND VGND VPWR VPWR sky130_fd_sc_hd__decap_8
XTAP_TAPCELL_ROW_61_557 VGND VPWR sky130_fd_sc_hd__tapvpwrvgnd_1
X_3871_ _1515_ _1516_ VGND VGND VPWR VPWR _1527_ sky130_fd_sc_hd__nor2_1
X_3940_ _1595_ _1592_ _1355_ VGND VGND VPWR VPWR _1596_ sky130_fd_sc_hd__a21oi_1
XFILLER_0_90_9 VGND VGND VPWR VPWR sky130_fd_sc_hd__fill_1
X_5541_ _2427_ reg_file.memory\[21\]\[9\] _2760_ VGND VGND VPWR VPWR _2770_ sky130_fd_sc_hd__mux2_1
X_5610_ _2427_ reg_file.memory\[25\]\[9\] _2797_ VGND VGND VPWR VPWR _2807_ sky130_fd_sc_hd__mux2_1
XFILLER_0_5_225 VPWR VGND VPWR VGND sky130_ef_sc_hd__decap_12
X_5472_ reg_file.memory\[1\]\[8\] VGND VGND VPWR VPWR _2734_ sky130_fd_sc_hd__clkbuf_1
XTAP_TAPCELL_ROW_69_602 VGND VPWR sky130_fd_sc_hd__tapvpwrvgnd_1
X_4285_ _1924_ _1927_ VGND VGND VPWR VPWR _1928_ sky130_fd_sc_hd__nor2_1
X_4423_ _2056_ _1203_ _2044_ _1907_ VGND VGND VPWR VPWR _2058_ sky130_fd_sc_hd__o31ai_1
X_4354_ _1296_ _1954_ _1907_ _1979_ _1993_ VGND VGND VPWR VPWR _0533_ sky130_fd_sc_hd__a221o_1
X_6024_ clknet_leaf_16_clk _0259_ VGND VGND VPWR VPWR reg_file.memory\[8\]\[22\] sky130_fd_sc_hd__dfxtp_1
X_3305_ _0598_ _0969_ VGND VGND VPWR VPWR _0970_ sky130_fd_sc_hd__or2_1
XFILLER_0_68_209 VGND VGND VPWR VPWR sky130_fd_sc_hd__decap_4
X_3098_ reg_file.memory\[15\]\[24\] _0554_ _0618_ _0762_ VGND VGND VPWR VPWR _0763_
+ sky130_fd_sc_hd__a211o_1
X_3236_ _0893_ _0900_ VGND VGND VPWR VPWR _0901_ sky130_fd_sc_hd__nand2_1
X_3167_ reg_file.memory\[5\]\[20\] _0831_ _0648_ VGND VGND VPWR VPWR _0832_ sky130_fd_sc_hd__mux2_1
XFILLER_0_76_220 VGND VGND VPWR VPWR sky130_fd_sc_hd__fill_1
X_5739_ _0576_ _0557_ _2865_ _0671_ VGND VGND VPWR VPWR _0504_ sky130_fd_sc_hd__o31ai_1
XTAP_TAPCELL_ROW_52_502 VGND VPWR sky130_fd_sc_hd__tapvpwrvgnd_1
XFILLER_0_36_139 VGND VGND VPWR VPWR sky130_fd_sc_hd__fill_1
X_5808_ _0510_ _0014_ VGND VGND VPWR VPWR alu.ALUResult\[14\] sky130_fd_sc_hd__dlxtn_1
XFILLER_0_32_312 VGND VGND VPWR VPWR sky130_fd_sc_hd__fill_1
XTAP_TAPCELL_ROW_9_246 VGND VPWR sky130_fd_sc_hd__tapvpwrvgnd_1
XFILLER_0_35_19 VGND VGND VPWR VPWR sky130_fd_sc_hd__fill_2
XTAP_TAPCELL_ROW_75_638 VGND VPWR sky130_fd_sc_hd__tapvpwrvgnd_1
XTAP_TAPCELL_ROW_0_190 VGND VPWR sky130_fd_sc_hd__tapvpwrvgnd_1
Xclkload16 clknet_leaf_3_clk VGND VGND VPWR VPWR clkload16/Y sky130_fd_sc_hd__inv_12
XFILLER_0_76_26 VGND VGND VPWR VPWR sky130_fd_sc_hd__fill_2
X_3021_ reg_file.memory\[8\]\[29\] reg_file.memory\[9\]\[29\] _0641_ VGND VGND VPWR
+ VPWR _0686_ sky130_fd_sc_hd__mux2_1
X_4070_ _0705_ _1671_ VGND VGND VPWR VPWR _1716_ sky130_fd_sc_hd__nand2_1
X_4972_ alu.ALUResult\[29\] VGND VGND VPWR VPWR _2469_ sky130_fd_sc_hd__clkbuf_2
XFILLER_0_73_223 VGND VGND VPWR VPWR sky130_fd_sc_hd__fill_1
X_3854_ _1502_ _1509_ _1506_ _1507_ _1361_ VGND VGND VPWR VPWR _1510_ sky130_fd_sc_hd__a311o_1
X_3923_ _1574_ _1578_ VGND VGND VPWR VPWR _1579_ sky130_fd_sc_hd__and2_1
X_5455_ _2725_ VGND VGND VPWR VPWR _0364_ sky130_fd_sc_hd__clkbuf_1
X_5524_ _2761_ VGND VGND VPWR VPWR _0397_ sky130_fd_sc_hd__clkbuf_1
X_4406_ _1286_ _1994_ _2033_ _2042_ VGND VGND VPWR VPWR _0536_ sky130_fd_sc_hd__a211o_1
X_3785_ _1437_ _1440_ VGND VGND VPWR VPWR _1441_ sky130_fd_sc_hd__nand2_1
X_4268_ _1817_ _1818_ VGND VGND VPWR VPWR _1911_ sky130_fd_sc_hd__nand2_1
X_5386_ _2688_ VGND VGND VPWR VPWR _0332_ sky130_fd_sc_hd__clkbuf_1
X_4337_ _1290_ _1954_ _1907_ _1962_ _1977_ VGND VGND VPWR VPWR _0532_ sky130_fd_sc_hd__a221o_1
X_3219_ reg_file.memory\[25\]\[17\] _0883_ _0670_ VGND VGND VPWR VPWR _0884_ sky130_fd_sc_hd__mux2_2
XFILLER_0_1_294 VGND VGND VPWR VPWR sky130_fd_sc_hd__fill_2
XTAP_TAPCELL_ROW_6_227 VGND VPWR sky130_fd_sc_hd__tapvpwrvgnd_1
X_6007_ clknet_leaf_26_clk _0242_ VGND VGND VPWR VPWR reg_file.memory\[8\]\[5\] sky130_fd_sc_hd__dfxtp_1
X_4199_ _1786_ _1839_ _1843_ _1732_ VGND VGND VPWR VPWR _1844_ sky130_fd_sc_hd__a211o_1
XFILLER_0_64_201 VGND VGND VPWR VPWR sky130_fd_sc_hd__fill_1
XPHY_EDGE_ROW_59_Left_150 VGND VGND VPWR VPWR sky130_fd_sc_hd__decap_3
XFILLER_0_64_223 VPWR VGND VPWR VGND sky130_ef_sc_hd__decap_12
XFILLER_0_32_197 VGND VGND VPWR VPWR sky130_fd_sc_hd__fill_1
XFILLER_0_87_337 VGND VGND VPWR VPWR sky130_fd_sc_hd__fill_2
XFILLER_0_70_248 VGND VGND VPWR VPWR sky130_fd_sc_hd__fill_1
X_5240_ _2613_ VGND VGND VPWR VPWR _0261_ sky130_fd_sc_hd__clkbuf_1
X_3570_ _0714_ _0721_ _1234_ VGND VGND VPWR VPWR _1235_ sky130_fd_sc_hd__a21o_1
XFILLER_0_11_76 VGND VGND VPWR VPWR sky130_fd_sc_hd__fill_1
X_4122_ _1767_ VGND VGND VPWR VPWR _1768_ sky130_fd_sc_hd__clkbuf_4
X_4053_ _1682_ _1698_ VGND VGND VPWR VPWR _1699_ sky130_fd_sc_hd__nand2_1
X_5171_ _2461_ reg_file.memory\[7\]\[25\] _2570_ VGND VGND VPWR VPWR _2576_ sky130_fd_sc_hd__mux2_1
XTAP_TAPCELL_ROW_3_208 VGND VPWR sky130_fd_sc_hd__tapvpwrvgnd_1
XPHY_EDGE_ROW_18_Right_18 VGND VGND VPWR VPWR sky130_fd_sc_hd__decap_3
X_4955_ _2457_ reg_file.memory\[4\]\[23\] _2451_ VGND VGND VPWR VPWR _2458_ sky130_fd_sc_hd__mux2_1
XFILLER_0_36_40 VGND VGND VPWR VPWR sky130_fd_sc_hd__fill_2
X_3004_ _0668_ VGND VGND VPWR VPWR _0669_ sky130_fd_sc_hd__clkbuf_4
XPHY_EDGE_ROW_27_Right_27 VGND VGND VPWR VPWR sky130_fd_sc_hd__decap_3
X_4886_ alu.ALUResult\[1\] VGND VGND VPWR VPWR _2411_ sky130_fd_sc_hd__dlymetal6s2s_1
XFILLER_0_61_215 VGND VGND VPWR VPWR sky130_fd_sc_hd__fill_2
X_3837_ _1362_ _1490_ _1492_ VGND VGND VPWR VPWR _1493_ sky130_fd_sc_hd__or3_1
X_3906_ _1356_ _1559_ _1561_ VGND VGND VPWR VPWR _1562_ sky130_fd_sc_hd__or3_1
X_3768_ _1415_ VGND VGND VPWR VPWR _1424_ sky130_fd_sc_hd__inv_2
X_5369_ reg_file.memory\[10\]\[23\] alu.ALUResult\[23\] _2676_ VGND VGND VPWR VPWR
+ _2680_ sky130_fd_sc_hd__mux2_1
X_5438_ _2457_ reg_file.memory\[15\]\[23\] _2713_ VGND VGND VPWR VPWR _2717_ sky130_fd_sc_hd__mux2_1
X_5507_ _2751_ VGND VGND VPWR VPWR _0390_ sky130_fd_sc_hd__clkbuf_1
XPHY_EDGE_ROW_36_Right_36 VGND VGND VPWR VPWR sky130_fd_sc_hd__decap_3
X_3699_ seven_seg_conv.temp\[4\] alu.ALUResult\[4\] _1347_ VGND VGND VPWR VPWR _1355_
+ sky130_fd_sc_hd__mux2_1
XTAP_TAPCELL_ROW_85_700 VGND VPWR sky130_fd_sc_hd__tapvpwrvgnd_1
XFILLER_0_69_359 VGND VGND VPWR VPWR sky130_fd_sc_hd__fill_1
XPHY_EDGE_ROW_45_Right_45 VGND VGND VPWR VPWR sky130_fd_sc_hd__decap_3
XTAP_TAPCELL_ROW_25_343 VGND VPWR sky130_fd_sc_hd__tapvpwrvgnd_1
XPHY_EDGE_ROW_54_Right_54 VGND VGND VPWR VPWR sky130_fd_sc_hd__decap_3
XPHY_EDGE_ROW_63_Right_63 VGND VGND VPWR VPWR sky130_fd_sc_hd__decap_3
XTAP_TAPCELL_ROW_48_479 VGND VPWR sky130_fd_sc_hd__tapvpwrvgnd_1
X_4740_ clk_div.counter\[16\] _2328_ VGND VGND VPWR VPWR _2330_ sky130_fd_sc_hd__nand2_1
X_4671_ _1963_ _2222_ _2241_ _1737_ VGND VGND VPWR VPWR _2286_ sky130_fd_sc_hd__a211o_1
X_3622_ _1064_ _1189_ VGND VGND VPWR VPWR _1287_ sky130_fd_sc_hd__nand2_1
XFILLER_0_43_237 VGND VGND VPWR VPWR sky130_fd_sc_hd__fill_2
XTAP_TAPCELL_ROW_31_379 VGND VPWR sky130_fd_sc_hd__tapvpwrvgnd_1
XFILLER_0_28_201 VGND VGND VPWR VPWR sky130_fd_sc_hd__fill_1
XFILLER_0_22_42 VGND VGND VPWR VPWR sky130_fd_sc_hd__fill_1
XPHY_EDGE_ROW_72_Right_72 VGND VGND VPWR VPWR sky130_fd_sc_hd__decap_3
X_3553_ _0885_ _1216_ _1217_ VGND VGND VPWR VPWR _1218_ sky130_fd_sc_hd__o21a_1
X_5223_ _2604_ VGND VGND VPWR VPWR _0253_ sky130_fd_sc_hd__clkbuf_1
XFILLER_0_11_167 VGND VGND VPWR VPWR sky130_fd_sc_hd__fill_1
XFILLER_0_11_178 VGND VGND VPWR VPWR sky130_fd_sc_hd__fill_1
X_3484_ reg_file.memory\[8\]\[1\] reg_file.memory\[9\]\[1\] _0635_ VGND VGND VPWR
+ VPWR _1149_ sky130_fd_sc_hd__mux2_1
XPHY_EDGE_ROW_81_Right_81 VGND VGND VPWR VPWR sky130_fd_sc_hd__decap_3
X_4105_ _1679_ _1750_ VGND VGND VPWR VPWR _1751_ sky130_fd_sc_hd__nand2_1
X_4036_ _1675_ VGND VGND VPWR VPWR _1682_ sky130_fd_sc_hd__buf_2
XFILLER_0_47_72 VGND VGND VPWR VPWR sky130_fd_sc_hd__fill_2
XTAP_TAPCELL_ROW_39_424 VGND VPWR sky130_fd_sc_hd__tapvpwrvgnd_1
X_5085_ _2530_ VGND VGND VPWR VPWR _0189_ sky130_fd_sc_hd__clkbuf_1
X_5154_ _2444_ reg_file.memory\[7\]\[17\] _2559_ VGND VGND VPWR VPWR _2567_ sky130_fd_sc_hd__mux2_1
X_4938_ alu.ALUResult\[18\] VGND VGND VPWR VPWR _2446_ sky130_fd_sc_hd__dlymetal6s2s_1
X_5987_ clknet_leaf_19_clk _0222_ VGND VGND VPWR VPWR reg_file.memory\[7\]\[17\] sky130_fd_sc_hd__dfxtp_1
XTAP_TAPCELL_ROW_22_324 VGND VPWR sky130_fd_sc_hd__tapvpwrvgnd_1
XPHY_EDGE_ROW_90_Right_90 VGND VGND VPWR VPWR sky130_fd_sc_hd__decap_3
X_4869_ _2398_ VGND VGND VPWR VPWR _0105_ sky130_fd_sc_hd__clkbuf_1
XFILLER_0_65_362 VGND VGND VPWR VPWR sky130_fd_sc_hd__fill_2
XFILLER_0_33_281 VGND VGND VPWR VPWR sky130_fd_sc_hd__fill_1
XFILLER_0_0_337 VPWR VGND VPWR VGND sky130_ef_sc_hd__decap_12
XFILLER_0_0_326 VGND VGND VPWR VPWR sky130_fd_sc_hd__decap_8
X_2984_ _0648_ VGND VGND VPWR VPWR _0649_ sky130_fd_sc_hd__clkbuf_4
XTAP_TAPCELL_ROW_36_405 VGND VPWR sky130_fd_sc_hd__tapvpwrvgnd_1
XFILLER_0_33_41 VGND VGND VPWR VPWR sky130_fd_sc_hd__fill_1
X_5910_ clknet_leaf_1_clk _0145_ VGND VGND VPWR VPWR reg_file.memory\[5\]\[4\] sky130_fd_sc_hd__dfxtp_1
X_5841_ clknet_leaf_20_clk _0091_ VGND VGND VPWR VPWR reg_file.memory\[9\]\[15\] sky130_fd_sc_hd__dfxtp_1
X_5772_ clk_div.slow_clk _0055_ VGND VGND VPWR VPWR seven_seg_conv.temp\[8\] sky130_fd_sc_hd__dfxtp_1
X_4723_ clk_div.counter\[8\] _2316_ clk_div.counter\[9\] VGND VGND VPWR VPWR _2320_
+ sky130_fd_sc_hd__a21oi_1
XFILLER_0_83_181 VPWR VGND VPWR VGND sky130_ef_sc_hd__decap_12
X_4654_ _2261_ _2262_ _2270_ VGND VGND VPWR VPWR _0526_ sky130_fd_sc_hd__o21ai_1
XFILLER_0_56_362 VGND VGND VPWR VPWR sky130_fd_sc_hd__fill_2
X_4585_ _2198_ _2206_ _0774_ VGND VGND VPWR VPWR _2207_ sky130_fd_sc_hd__o21a_1
X_3605_ _0774_ _1227_ VGND VGND VPWR VPWR _1270_ sky130_fd_sc_hd__xor2_1
XFILLER_0_16_248 VGND VGND VPWR VPWR sky130_fd_sc_hd__fill_1
X_6255_ clknet_leaf_11_clk _0490_ VGND VGND VPWR VPWR reg_file.memory\[2\]\[29\] sky130_fd_sc_hd__dfxtp_1
X_6186_ clknet_leaf_14_clk _0421_ VGND VGND VPWR VPWR reg_file.memory\[21\]\[24\]
+ sky130_fd_sc_hd__dfxtp_1
X_3467_ _1109_ _1131_ VGND VGND VPWR VPWR _1132_ sky130_fd_sc_hd__nand2_1
X_3536_ _1014_ _1198_ _1200_ VGND VGND VPWR VPWR _1201_ sky130_fd_sc_hd__a21o_1
X_3398_ reg_file.memory\[25\]\[6\] _1062_ _0669_ VGND VGND VPWR VPWR _1063_ sky130_fd_sc_hd__mux2_2
X_5206_ _2595_ VGND VGND VPWR VPWR _0245_ sky130_fd_sc_hd__clkbuf_1
X_4019_ _0627_ _0682_ _1664_ VGND VGND VPWR VPWR _1665_ sky130_fd_sc_hd__and3_1
X_5137_ _2427_ reg_file.memory\[7\]\[9\] _2548_ VGND VGND VPWR VPWR _2558_ sky130_fd_sc_hd__mux2_1
X_5068_ _2521_ VGND VGND VPWR VPWR _0181_ sky130_fd_sc_hd__clkbuf_1
XFILLER_0_90_80 VGND VGND VPWR VPWR sky130_fd_sc_hd__decap_4
XFILLER_0_81_129 VGND VGND VPWR VPWR sky130_fd_sc_hd__decap_8
XFILLER_0_66_115 VGND VGND VPWR VPWR sky130_fd_sc_hd__fill_1
XFILLER_0_47_362 VGND VGND VPWR VPWR sky130_fd_sc_hd__fill_2
XPHY_EDGE_ROW_0_Right_0 VGND VGND VPWR VPWR sky130_fd_sc_hd__decap_3
XFILLER_0_89_207 VGND VGND VPWR VPWR sky130_fd_sc_hd__decap_8
XTAP_TAPCELL_ROW_58_541 VGND VPWR sky130_fd_sc_hd__tapvpwrvgnd_1
XFILLER_0_57_126 VPWR VGND VPWR VGND sky130_ef_sc_hd__decap_12
XFILLER_0_80_195 VGND VGND VPWR VPWR sky130_fd_sc_hd__fill_1
X_4370_ _1921_ _1913_ _1767_ VGND VGND VPWR VPWR _2009_ sky130_fd_sc_hd__mux2_1
X_3321_ _0598_ _0985_ VGND VGND VPWR VPWR _0986_ sky130_fd_sc_hd__or2_1
XFILLER_0_0_101 VGND VGND VPWR VPWR sky130_fd_sc_hd__decap_4
XPHY_EDGE_ROW_13_Left_104 VGND VGND VPWR VPWR sky130_fd_sc_hd__decap_3
X_3252_ _0914_ _0916_ _0664_ VGND VGND VPWR VPWR _0917_ sky130_fd_sc_hd__mux2_1
X_6040_ clknet_leaf_0_clk _0275_ VGND VGND VPWR VPWR reg_file.memory\[0\]\[6\] sky130_fd_sc_hd__dfxtp_1
X_3183_ reg_file.memory\[5\]\[19\] _0847_ _0648_ VGND VGND VPWR VPWR _0848_ sky130_fd_sc_hd__mux2_1
X_5755_ clknet_leaf_6_clk _0039_ VGND VGND VPWR VPWR clk_div.counter\[10\] sky130_fd_sc_hd__dfxtp_1
X_2967_ _0539_ PC\[1\] VGND VGND VPWR VPWR _0632_ sky130_fd_sc_hd__nand2_1
XTAP_TAPCELL_ROW_64_577 VGND VPWR sky130_fd_sc_hd__tapvpwrvgnd_1
X_5824_ _0528_ _0014_ VGND VGND VPWR VPWR alu.ALUResult\[30\] sky130_fd_sc_hd__dlxtn_1
XPHY_EDGE_ROW_22_Left_113 VGND VGND VPWR VPWR sky130_fd_sc_hd__decap_3
X_4706_ clk_div.counter\[3\] clk_div.counter\[4\] _2304_ VGND VGND VPWR VPWR _2308_
+ sky130_fd_sc_hd__and3_1
X_2898_ _0540_ _0562_ VGND VGND VPWR VPWR _0563_ sky130_fd_sc_hd__nand2_1
X_4568_ _2170_ _2191_ _1719_ VGND VGND VPWR VPWR _2192_ sky130_fd_sc_hd__mux2_1
X_4637_ _0714_ _2254_ VGND VGND VPWR VPWR _2255_ sky130_fd_sc_hd__nand2_1
XPHY_EDGE_ROW_31_Left_122 VGND VGND VPWR VPWR sky130_fd_sc_hd__decap_3
X_5686_ reg_file.memory\[2\]\[14\] VGND VGND VPWR VPWR _2846_ sky130_fd_sc_hd__clkbuf_1
X_4499_ _1091_ _1741_ VGND VGND VPWR VPWR _2129_ sky130_fd_sc_hd__nor2_1
X_3519_ _1091_ _1098_ _1181_ _1183_ VGND VGND VPWR VPWR _1184_ sky130_fd_sc_hd__a22o_1
X_6169_ clknet_leaf_2_clk _0404_ VGND VGND VPWR VPWR reg_file.memory\[21\]\[7\] sky130_fd_sc_hd__dfxtp_1
X_6238_ clknet_leaf_23_clk _0473_ VGND VGND VPWR VPWR reg_file.memory\[2\]\[12\] sky130_fd_sc_hd__dfxtp_1
XTAP_TAPCELL_ROW_55_522 VGND VPWR sky130_fd_sc_hd__tapvpwrvgnd_1
XFILLER_0_39_126 VGND VGND VPWR VPWR sky130_fd_sc_hd__fill_2
XPHY_EDGE_ROW_40_Left_131 VGND VGND VPWR VPWR sky130_fd_sc_hd__decap_3
XFILLER_0_47_181 VPWR VGND VPWR VGND sky130_ef_sc_hd__decap_12
Xclkbuf_leaf_20_clk clknet_1_0__leaf_clk VGND VGND VPWR VPWR clknet_leaf_20_clk sky130_fd_sc_hd__clkbuf_8
XFILLER_0_62_195 VGND VGND VPWR VPWR sky130_fd_sc_hd__fill_1
XTAP_TAPCELL_ROW_78_658 VGND VPWR sky130_fd_sc_hd__tapvpwrvgnd_1
XTAP_TAPCELL_ROW_61_558 VGND VPWR sky130_fd_sc_hd__tapvpwrvgnd_1
X_3870_ _1523_ _1524_ _1525_ VGND VGND VPWR VPWR _1526_ sky130_fd_sc_hd__or3_1
Xclkbuf_leaf_11_clk clknet_1_1__leaf_clk VGND VGND VPWR VPWR clknet_leaf_11_clk sky130_fd_sc_hd__clkbuf_8
X_4422_ _2056_ _2044_ _1203_ VGND VGND VPWR VPWR _2057_ sky130_fd_sc_hd__o21a_1
XFILLER_0_41_335 VGND VGND VPWR VPWR sky130_fd_sc_hd__fill_1
X_5540_ _2769_ VGND VGND VPWR VPWR _0405_ sky130_fd_sc_hd__clkbuf_1
XFILLER_0_5_248 VGND VGND VPWR VPWR sky130_fd_sc_hd__decap_3
X_5471_ _2733_ VGND VGND VPWR VPWR _0372_ sky130_fd_sc_hd__clkbuf_1
XTAP_TAPCELL_ROW_69_603 VGND VPWR sky130_fd_sc_hd__tapvpwrvgnd_1
X_4284_ _1767_ _1926_ VGND VGND VPWR VPWR _1927_ sky130_fd_sc_hd__or2_1
X_4353_ _1744_ _1989_ _1992_ _1800_ _1952_ VGND VGND VPWR VPWR _1993_ sky130_fd_sc_hd__o221a_1
X_6023_ clknet_leaf_16_clk _0258_ VGND VGND VPWR VPWR reg_file.memory\[8\]\[21\] sky130_fd_sc_hd__dfxtp_1
X_3235_ reg_file.memory\[25\]\[16\] _0899_ _0670_ VGND VGND VPWR VPWR _0900_ sky130_fd_sc_hd__mux2_2
X_3304_ reg_file.memory\[0\]\[11\] reg_file.memory\[1\]\[11\] _0591_ VGND VGND VPWR
+ VPWR _0969_ sky130_fd_sc_hd__mux2_1
XFILLER_0_76_232 VGND VGND VPWR VPWR sky130_fd_sc_hd__fill_2
X_3097_ _0757_ _0761_ _0612_ VGND VGND VPWR VPWR _0762_ sky130_fd_sc_hd__o21a_1
XTAP_TAPCELL_ROW_52_503 VGND VPWR sky130_fd_sc_hd__tapvpwrvgnd_1
X_3166_ reg_file.memory\[6\]\[20\] reg_file.memory\[7\]\[20\] _0639_ VGND VGND VPWR
+ VPWR _0831_ sky130_fd_sc_hd__mux2_1
X_5738_ _2869_ VGND VGND VPWR VPWR _0503_ sky130_fd_sc_hd__clkbuf_1
XFILLER_0_71_93 VGND VGND VPWR VPWR sky130_fd_sc_hd__fill_1
X_5807_ _0509_ _0014_ VGND VGND VPWR VPWR alu.ALUResult\[13\] sky130_fd_sc_hd__dlxtn_1
X_3999_ _0016_ _0018_ VGND VGND VPWR VPWR _1648_ sky130_fd_sc_hd__nor2_1
XTAP_TAPCELL_ROW_17_290 VGND VPWR sky130_fd_sc_hd__tapvpwrvgnd_1
X_5669_ _2837_ VGND VGND VPWR VPWR _0466_ sky130_fd_sc_hd__clkbuf_1
XFILLER_0_4_281 VGND VGND VPWR VPWR sky130_fd_sc_hd__decap_3
XTAP_TAPCELL_ROW_9_247 VGND VPWR sky130_fd_sc_hd__tapvpwrvgnd_1
XTAP_TAPCELL_ROW_75_639 VGND VPWR sky130_fd_sc_hd__tapvpwrvgnd_1
XTAP_TAPCELL_ROW_0_191 VGND VPWR sky130_fd_sc_hd__tapvpwrvgnd_1
Xclkload17 clknet_leaf_4_clk VGND VGND VPWR VPWR clkload17/Y sky130_fd_sc_hd__clkinv_4
XFILLER_0_50_176 VGND VGND VPWR VPWR sky130_fd_sc_hd__decap_3
XFILLER_0_50_121 VPWR VGND VPWR VGND sky130_ef_sc_hd__decap_12
XFILLER_0_50_187 VGND VGND VPWR VPWR sky130_fd_sc_hd__decap_8
X_4971_ _2468_ VGND VGND VPWR VPWR _0137_ sky130_fd_sc_hd__clkbuf_1
X_3020_ reg_file.memory\[0\]\[29\] _0684_ _0656_ VGND VGND VPWR VPWR _0685_ sky130_fd_sc_hd__mux2_1
Xclkbuf_leaf_0_clk clknet_1_0__leaf_clk VGND VGND VPWR VPWR clknet_leaf_0_clk sky130_fd_sc_hd__clkbuf_8
X_3853_ _1500_ _1501_ VGND VGND VPWR VPWR _1509_ sky130_fd_sc_hd__nor2_1
X_3922_ _1575_ _1577_ _1573_ _1572_ VGND VGND VPWR VPWR _1578_ sky130_fd_sc_hd__o211ai_1
X_3784_ _1435_ _1439_ VGND VGND VPWR VPWR _1440_ sky130_fd_sc_hd__and2_1
X_5385_ reg_file.memory\[10\]\[31\] alu.ALUResult\[31\] _2653_ VGND VGND VPWR VPWR
+ _2688_ sky130_fd_sc_hd__mux2_1
X_5454_ _2367_ reg_file.memory\[15\]\[31\] _2690_ VGND VGND VPWR VPWR _2725_ sky130_fd_sc_hd__mux2_1
X_5523_ _2401_ reg_file.memory\[21\]\[0\] _2760_ VGND VGND VPWR VPWR _2761_ sky130_fd_sc_hd__mux2_1
X_4405_ _2001_ _2034_ _2040_ _2041_ VGND VGND VPWR VPWR _2042_ sky130_fd_sc_hd__o211a_1
X_4336_ _1744_ _1972_ _1975_ _1976_ _1952_ VGND VGND VPWR VPWR _1977_ sky130_fd_sc_hd__o221a_1
XFILLER_0_41_198 VPWR VGND VPWR VGND sky130_ef_sc_hd__decap_12
X_4198_ _1786_ _1842_ VGND VGND VPWR VPWR _1843_ sky130_fd_sc_hd__nor2_1
X_4267_ _1179_ _1291_ VGND VGND VPWR VPWR _1910_ sky130_fd_sc_hd__xnor2_1
X_3149_ reg_file.memory\[21\]\[21\] _0545_ _0626_ _0813_ VGND VGND VPWR VPWR _0814_
+ sky130_fd_sc_hd__o211ai_2
XFILLER_0_5_52 VGND VGND VPWR VPWR sky130_fd_sc_hd__decap_4
XTAP_TAPCELL_ROW_6_228 VGND VPWR sky130_fd_sc_hd__tapvpwrvgnd_1
X_3218_ _0880_ _0882_ _0664_ VGND VGND VPWR VPWR _0883_ sky130_fd_sc_hd__mux2_1
X_6006_ clknet_leaf_27_clk _0241_ VGND VGND VPWR VPWR reg_file.memory\[8\]\[4\] sky130_fd_sc_hd__dfxtp_1
XFILLER_0_64_235 VGND VGND VPWR VPWR sky130_fd_sc_hd__fill_2
XFILLER_0_49_298 VGND VGND VPWR VPWR sky130_fd_sc_hd__fill_1
XFILLER_0_64_279 VGND VGND VPWR VPWR sky130_fd_sc_hd__fill_1
XTAP_TAPCELL_ROW_88_720 VGND VPWR sky130_fd_sc_hd__tapvpwrvgnd_1
XFILLER_0_1_3 VPWR VGND VPWR VGND sky130_ef_sc_hd__decap_12
XFILLER_0_23_110 VGND VGND VPWR VPWR sky130_fd_sc_hd__fill_2
X_4052_ _0900_ _1697_ VGND VGND VPWR VPWR _1698_ sky130_fd_sc_hd__nand2_1
X_5170_ _2575_ VGND VGND VPWR VPWR _0229_ sky130_fd_sc_hd__clkbuf_1
X_3003_ _0667_ VGND VGND VPWR VPWR _0668_ sky130_fd_sc_hd__clkbuf_4
X_4121_ _1128_ VGND VGND VPWR VPWR _1767_ sky130_fd_sc_hd__clkbuf_4
XTAP_TAPCELL_ROW_3_209 VGND VPWR sky130_fd_sc_hd__tapvpwrvgnd_1
X_4954_ alu.ALUResult\[23\] VGND VGND VPWR VPWR _2457_ sky130_fd_sc_hd__clkbuf_2
XFILLER_0_36_85 VGND VGND VPWR VPWR sky130_fd_sc_hd__fill_2
X_3905_ _1552_ _1556_ _1558_ VGND VGND VPWR VPWR _1561_ sky130_fd_sc_hd__and3_1
X_5506_ reg_file.memory\[1\]\[25\] VGND VGND VPWR VPWR _2751_ sky130_fd_sc_hd__clkbuf_1
X_4885_ _2410_ VGND VGND VPWR VPWR _0109_ sky130_fd_sc_hd__clkbuf_1
X_3836_ _1483_ _1487_ _1489_ VGND VGND VPWR VPWR _1492_ sky130_fd_sc_hd__and3_1
X_3767_ _1419_ _1422_ VGND VGND VPWR VPWR _1423_ sky130_fd_sc_hd__nand2_1
X_5437_ _2716_ VGND VGND VPWR VPWR _0355_ sky130_fd_sc_hd__clkbuf_1
X_5299_ reg_file.memory\[0\]\[22\] VGND VGND VPWR VPWR _2643_ sky130_fd_sc_hd__clkbuf_1
X_4319_ _1654_ _1098_ VGND VGND VPWR VPWR _1960_ sky130_fd_sc_hd__nand2_1
X_5368_ _2679_ VGND VGND VPWR VPWR _0323_ sky130_fd_sc_hd__clkbuf_1
X_3698_ alu.ALUResult\[2\] seven_seg_conv.temp\[2\] _1352_ VGND VGND VPWR VPWR _1354_
+ sky130_fd_sc_hd__mux2_1
XTAP_TAPCELL_ROW_85_701 VGND VPWR sky130_fd_sc_hd__tapvpwrvgnd_1
XFILLER_0_37_202 VGND VGND VPWR VPWR sky130_fd_sc_hd__decap_3
XFILLER_0_57_29 VGND VGND VPWR VPWR sky130_fd_sc_hd__fill_2
X_4670_ _1963_ _1824_ _1789_ VGND VGND VPWR VPWR _2285_ sky130_fd_sc_hd__o21ai_1
XPHY_EDGE_ROW_78_Left_169 VGND VGND VPWR VPWR sky130_fd_sc_hd__decap_3
X_3621_ _1285_ _1197_ VGND VGND VPWR VPWR _1286_ sky130_fd_sc_hd__xnor2_1
XFILLER_0_43_249 VGND VGND VPWR VPWR sky130_fd_sc_hd__fill_1
X_3552_ _0862_ _0869_ VGND VGND VPWR VPWR _1217_ sky130_fd_sc_hd__xor2_2
XFILLER_0_7_107 VGND VGND VPWR VPWR sky130_fd_sc_hd__decap_4
X_3483_ reg_file.memory\[0\]\[1\] _1147_ _0653_ VGND VGND VPWR VPWR _1148_ sky130_fd_sc_hd__mux2_1
XFILLER_0_3_357 VGND VGND VPWR VPWR sky130_fd_sc_hd__decap_6
X_5222_ reg_file.memory\[8\]\[16\] alu.ALUResult\[16\] _2597_ VGND VGND VPWR VPWR
+ _2604_ sky130_fd_sc_hd__mux2_1
X_5153_ _2566_ VGND VGND VPWR VPWR _0221_ sky130_fd_sc_hd__clkbuf_1
XPHY_EDGE_ROW_87_Left_178 VGND VGND VPWR VPWR sky130_fd_sc_hd__decap_3
X_4035_ _1679_ _1680_ VGND VGND VPWR VPWR _1681_ sky130_fd_sc_hd__nand2_1
X_4104_ _0950_ _1697_ VGND VGND VPWR VPWR _1750_ sky130_fd_sc_hd__nand2_1
XFILLER_0_47_84 VGND VGND VPWR VPWR sky130_fd_sc_hd__fill_1
XTAP_TAPCELL_ROW_39_425 VGND VPWR sky130_fd_sc_hd__tapvpwrvgnd_1
X_5084_ _2442_ reg_file.memory\[6\]\[16\] _2523_ VGND VGND VPWR VPWR _2530_ sky130_fd_sc_hd__mux2_1
X_4868_ reg_file.memory\[9\]\[29\] VGND VGND VPWR VPWR _2398_ sky130_fd_sc_hd__clkbuf_1
X_4937_ _2445_ VGND VGND VPWR VPWR _0126_ sky130_fd_sc_hd__clkbuf_1
X_5986_ clknet_leaf_19_clk _0221_ VGND VGND VPWR VPWR reg_file.memory\[7\]\[16\] sky130_fd_sc_hd__dfxtp_1
XTAP_TAPCELL_ROW_22_325 VGND VPWR sky130_fd_sc_hd__tapvpwrvgnd_1
X_4799_ seven_seg_conv.temp\[23\] _2363_ _1635_ VGND VGND VPWR VPWR _2364_ sky130_fd_sc_hd__mux2_1
X_3819_ _1469_ _1471_ VGND VGND VPWR VPWR _1475_ sky130_fd_sc_hd__and2_1
XFILLER_0_65_352 VGND VGND VPWR VPWR sky130_fd_sc_hd__fill_1
XFILLER_0_0_349 VGND VGND VPWR VPWR sky130_fd_sc_hd__decap_3
XFILLER_0_84_27 VGND VGND VPWR VPWR sky130_fd_sc_hd__fill_1
XTAP_TAPCELL_ROW_36_406 VGND VPWR sky130_fd_sc_hd__tapvpwrvgnd_1
X_4722_ clk_div.counter\[9\] clk_div.counter\[8\] _2316_ VGND VGND VPWR VPWR _2319_
+ sky130_fd_sc_hd__and3_1
XFILLER_0_75_127 VPWR VGND VPWR VGND sky130_ef_sc_hd__decap_12
X_5840_ clknet_leaf_20_clk _0090_ VGND VGND VPWR VPWR reg_file.memory\[9\]\[14\] sky130_fd_sc_hd__dfxtp_1
X_2983_ _0647_ VGND VGND VPWR VPWR _0648_ sky130_fd_sc_hd__clkbuf_4
X_5771_ clk_div.slow_clk _0054_ VGND VGND VPWR VPWR seven_seg_conv.temp\[7\] sky130_fd_sc_hd__dfxtp_1
XFILLER_0_83_193 VGND VGND VPWR VPWR sky130_fd_sc_hd__decap_4
X_4653_ _2263_ _2269_ _1323_ _2059_ VGND VGND VPWR VPWR _2270_ sky130_fd_sc_hd__o2bb2a_1
X_4584_ _0782_ _0789_ VGND VGND VPWR VPWR _2206_ sky130_fd_sc_hd__and2b_1
X_3604_ _1268_ _1228_ VGND VGND VPWR VPWR _1269_ sky130_fd_sc_hd__xnor2_1
X_3535_ _0998_ _1199_ VGND VGND VPWR VPWR _1200_ sky130_fd_sc_hd__nand2_1
XFILLER_0_16_227 VGND VGND VPWR VPWR sky130_fd_sc_hd__fill_2
X_6185_ clknet_leaf_9_clk _0420_ VGND VGND VPWR VPWR reg_file.memory\[21\]\[23\] sky130_fd_sc_hd__dfxtp_1
X_6254_ clknet_leaf_11_clk _0489_ VGND VGND VPWR VPWR reg_file.memory\[2\]\[28\] sky130_fd_sc_hd__dfxtp_1
X_3466_ reg_file.memory\[0\]\[2\] _1130_ _0653_ VGND VGND VPWR VPWR _1131_ sky130_fd_sc_hd__mux2_1
X_5136_ _2557_ VGND VGND VPWR VPWR _0213_ sky130_fd_sc_hd__clkbuf_1
X_5205_ reg_file.memory\[8\]\[8\] alu.ALUResult\[8\] _2586_ VGND VGND VPWR VPWR _2595_
+ sky130_fd_sc_hd__mux2_1
X_3397_ _1059_ _1061_ _0663_ VGND VGND VPWR VPWR _1062_ sky130_fd_sc_hd__mux2_1
X_4018_ _0698_ _0714_ _0730_ _0746_ VGND VGND VPWR VPWR _1664_ sky130_fd_sc_hd__and4_1
X_5067_ _2425_ reg_file.memory\[6\]\[8\] _2512_ VGND VGND VPWR VPWR _2521_ sky130_fd_sc_hd__mux2_1
XFILLER_0_81_119 VGND VGND VPWR VPWR sky130_fd_sc_hd__fill_1
XFILLER_0_81_108 VGND VGND VPWR VPWR sky130_fd_sc_hd__decap_4
XFILLER_0_74_182 VPWR VGND VPWR VGND sky130_ef_sc_hd__decap_12
X_5969_ clknet_leaf_13_clk _0204_ VGND VGND VPWR VPWR reg_file.memory\[6\]\[31\] sky130_fd_sc_hd__dfxtp_1
XFILLER_0_54_19 VGND VGND VPWR VPWR sky130_fd_sc_hd__fill_1
XFILLER_0_72_108 VGND VGND VPWR VPWR sky130_fd_sc_hd__fill_2
XFILLER_0_57_138 VGND VGND VPWR VPWR sky130_fd_sc_hd__decap_8
XFILLER_0_38_363 VGND VGND VPWR VPWR sky130_fd_sc_hd__fill_1
XFILLER_0_80_141 VPWR VGND VPWR VGND sky130_ef_sc_hd__decap_12
X_3320_ reg_file.memory\[0\]\[10\] reg_file.memory\[1\]\[10\] _0591_ VGND VGND VPWR
+ VPWR _0985_ sky130_fd_sc_hd__mux2_1
XFILLER_0_0_113 VGND VGND VPWR VPWR sky130_fd_sc_hd__fill_1
XFILLER_0_0_124 VPWR VGND VPWR VGND sky130_ef_sc_hd__decap_12
X_3251_ _0915_ reg_file.memory\[10\]\[15\] _0647_ VGND VGND VPWR VPWR _0916_ sky130_fd_sc_hd__mux2_1
X_3182_ reg_file.memory\[6\]\[19\] reg_file.memory\[7\]\[19\] _0639_ VGND VGND VPWR
+ VPWR _0847_ sky130_fd_sc_hd__mux2_1
XFILLER_0_48_105 VGND VGND VPWR VPWR sky130_fd_sc_hd__decap_3
X_4705_ clk_div.counter\[3\] _2304_ VGND VGND VPWR VPWR _0032_ sky130_fd_sc_hd__xor2_1
X_5754_ clknet_leaf_6_clk _0038_ VGND VGND VPWR VPWR clk_div.counter\[9\] sky130_fd_sc_hd__dfxtp_1
X_2897_ _0561_ _0550_ VGND VGND VPWR VPWR _0562_ sky130_fd_sc_hd__nor2_1
X_2966_ _0540_ _0539_ VGND VGND VPWR VPWR _0631_ sky130_fd_sc_hd__nand2_1
X_5823_ _0526_ _0014_ VGND VGND VPWR VPWR alu.ALUResult\[29\] sky130_fd_sc_hd__dlxtn_2
XFILLER_0_63_108 VGND VGND VPWR VPWR sky130_fd_sc_hd__decap_4
XFILLER_0_60_51 VGND VGND VPWR VPWR sky130_fd_sc_hd__fill_1
X_5685_ _2845_ VGND VGND VPWR VPWR _0474_ sky130_fd_sc_hd__clkbuf_1
XFILLER_0_69_93 VPWR VGND VPWR VGND sky130_ef_sc_hd__decap_12
X_4567_ _2190_ VGND VGND VPWR VPWR _2191_ sky130_fd_sc_hd__inv_2
X_4498_ _2073_ _2127_ _1737_ VGND VGND VPWR VPWR _2128_ sky130_fd_sc_hd__mux2_1
X_4636_ _0721_ VGND VGND VPWR VPWR _2254_ sky130_fd_sc_hd__inv_2
X_3518_ _1182_ VGND VGND VPWR VPWR _1183_ sky130_fd_sc_hd__inv_2
XFILLER_0_8_85 VGND VGND VPWR VPWR sky130_fd_sc_hd__fill_2
X_6099_ clknet_leaf_4_clk _0334_ VGND VGND VPWR VPWR reg_file.memory\[15\]\[1\] sky130_fd_sc_hd__dfxtp_1
X_5119_ _2401_ reg_file.memory\[7\]\[0\] _2548_ VGND VGND VPWR VPWR _2549_ sky130_fd_sc_hd__mux2_1
X_6168_ clknet_leaf_2_clk _0403_ VGND VGND VPWR VPWR reg_file.memory\[21\]\[6\] sky130_fd_sc_hd__dfxtp_1
X_6237_ clknet_leaf_23_clk _0472_ VGND VGND VPWR VPWR reg_file.memory\[2\]\[11\] sky130_fd_sc_hd__dfxtp_1
X_3449_ reg_file.memory\[8\]\[3\] reg_file.memory\[9\]\[3\] _0636_ VGND VGND VPWR
+ VPWR _1114_ sky130_fd_sc_hd__mux2_1
XTAP_TAPCELL_ROW_55_523 VGND VPWR sky130_fd_sc_hd__tapvpwrvgnd_1
XFILLER_0_39_138 VGND VGND VPWR VPWR sky130_fd_sc_hd__decap_8
XFILLER_0_62_141 VPWR VGND VPWR VGND sky130_ef_sc_hd__decap_12
XFILLER_0_47_193 VPWR VGND VPWR VGND sky130_ef_sc_hd__decap_12
XTAP_TAPCELL_ROW_78_659 VGND VPWR sky130_fd_sc_hd__tapvpwrvgnd_1
XFILLER_0_85_299 VGND VGND VPWR VPWR sky130_fd_sc_hd__fill_2
XFILLER_0_85_222 VGND VGND VPWR VPWR sky130_fd_sc_hd__fill_2
XTAP_TAPCELL_ROW_61_559 VGND VPWR sky130_fd_sc_hd__tapvpwrvgnd_1
XFILLER_0_14_77 VGND VGND VPWR VPWR sky130_fd_sc_hd__fill_1
X_4352_ _1789_ _1950_ _1893_ _1991_ VGND VGND VPWR VPWR _1992_ sky130_fd_sc_hd__a31o_1
X_4421_ _0990_ _0997_ VGND VGND VPWR VPWR _2056_ sky130_fd_sc_hd__and2b_1
XFILLER_0_39_41 VGND VGND VPWR VPWR sky130_fd_sc_hd__fill_1
X_5470_ reg_file.memory\[1\]\[7\] VGND VGND VPWR VPWR _2733_ sky130_fd_sc_hd__clkbuf_1
X_4283_ _1866_ _1925_ _1686_ VGND VGND VPWR VPWR _1926_ sky130_fd_sc_hd__mux2_1
XTAP_TAPCELL_ROW_69_604 VGND VPWR sky130_fd_sc_hd__tapvpwrvgnd_1
X_3165_ reg_file.memory\[21\]\[20\] _0545_ _0625_ _0829_ VGND VGND VPWR VPWR _0830_
+ sky130_fd_sc_hd__o211ai_4
X_6022_ clknet_leaf_17_clk _0257_ VGND VGND VPWR VPWR reg_file.memory\[8\]\[20\] sky130_fd_sc_hd__dfxtp_1
X_3234_ _0896_ _0898_ _0664_ VGND VGND VPWR VPWR _0899_ sky130_fd_sc_hd__mux2_1
X_3303_ reg_file.memory\[4\]\[11\] reg_file.memory\[5\]\[11\] _0591_ VGND VGND VPWR
+ VPWR _0968_ sky130_fd_sc_hd__mux2_1
X_3096_ _0575_ _0758_ _0760_ _0607_ VGND VGND VPWR VPWR _0761_ sky130_fd_sc_hd__o211a_1
XFILLER_0_55_73 VPWR VGND VPWR VGND sky130_ef_sc_hd__decap_12
XTAP_TAPCELL_ROW_52_504 VGND VPWR sky130_fd_sc_hd__tapvpwrvgnd_1
X_5737_ _0546_ _0015_ VGND VGND VPWR VPWR _2869_ sky130_fd_sc_hd__and2_1
X_2949_ _0538_ _0542_ VGND VGND VPWR VPWR _0614_ sky130_fd_sc_hd__and2_1
X_5806_ _0508_ _0014_ VGND VGND VPWR VPWR alu.ALUResult\[12\] sky130_fd_sc_hd__dlxtn_1
XFILLER_0_32_303 VGND VGND VPWR VPWR sky130_fd_sc_hd__fill_2
X_5668_ reg_file.memory\[2\]\[5\] VGND VGND VPWR VPWR _2837_ sky130_fd_sc_hd__clkbuf_1
X_3998_ _1647_ VGND VGND VPWR VPWR _0003_ sky130_fd_sc_hd__clkbuf_1
XTAP_TAPCELL_ROW_17_291 VGND VPWR sky130_fd_sc_hd__tapvpwrvgnd_1
X_4619_ _1267_ _1994_ _2232_ _2238_ VGND VGND VPWR VPWR _0523_ sky130_fd_sc_hd__a211o_1
X_5599_ _2801_ VGND VGND VPWR VPWR _0432_ sky130_fd_sc_hd__clkbuf_1
XTAP_TAPCELL_ROW_0_192 VGND VPWR sky130_fd_sc_hd__tapvpwrvgnd_1
Xclkload18 clknet_leaf_5_clk VGND VGND VPWR VPWR clkload18/Y sky130_fd_sc_hd__inv_16
XFILLER_0_50_133 VGND VGND VPWR VPWR sky130_fd_sc_hd__decap_6
X_4970_ _2467_ reg_file.memory\[4\]\[28\] _2451_ VGND VGND VPWR VPWR _2468_ sky130_fd_sc_hd__mux2_1
X_3921_ _1576_ _1562_ _1560_ VGND VGND VPWR VPWR _1577_ sky130_fd_sc_hd__mux2_1
XFILLER_0_73_214 VGND VGND VPWR VPWR sky130_fd_sc_hd__fill_1
XFILLER_0_58_277 VGND VGND VPWR VPWR sky130_fd_sc_hd__decap_4
XFILLER_0_41_100 VGND VGND VPWR VPWR sky130_fd_sc_hd__fill_2
X_5522_ _2759_ VGND VGND VPWR VPWR _2760_ sky130_fd_sc_hd__clkbuf_4
X_3852_ _1498_ _1507_ VGND VGND VPWR VPWR _1508_ sky130_fd_sc_hd__xnor2_1
XTAP_TAPCELL_ROW_14_272 VGND VPWR sky130_fd_sc_hd__tapvpwrvgnd_1
X_3783_ _1426_ _1438_ _1432_ VGND VGND VPWR VPWR _1439_ sky130_fd_sc_hd__o21ai_1
X_5384_ _2687_ VGND VGND VPWR VPWR _0331_ sky130_fd_sc_hd__clkbuf_1
X_5453_ _2724_ VGND VGND VPWR VPWR _0363_ sky130_fd_sc_hd__clkbuf_1
X_4404_ _1952_ VGND VGND VPWR VPWR _2041_ sky130_fd_sc_hd__buf_2
X_4335_ _1091_ VGND VGND VPWR VPWR _1976_ sky130_fd_sc_hd__buf_2
XFILLER_0_41_166 VGND VGND VPWR VPWR sky130_fd_sc_hd__fill_2
XFILLER_0_41_155 VGND VGND VPWR VPWR sky130_fd_sc_hd__fill_1
XTAP_TAPCELL_ROW_6_229 VGND VPWR sky130_fd_sc_hd__tapvpwrvgnd_1
X_4197_ _1840_ _1841_ VGND VGND VPWR VPWR _1842_ sky130_fd_sc_hd__nand2_1
X_4266_ _1291_ _1908_ VGND VGND VPWR VPWR _1909_ sky130_fd_sc_hd__xnor2_1
X_3148_ reg_file.memory\[15\]\[21\] _0554_ _0618_ _0812_ VGND VGND VPWR VPWR _0813_
+ sky130_fd_sc_hd__a211o_1
X_3217_ _0881_ reg_file.memory\[10\]\[17\] _0647_ VGND VGND VPWR VPWR _0882_ sky130_fd_sc_hd__mux2_1
X_6005_ clknet_leaf_27_clk _0240_ VGND VGND VPWR VPWR reg_file.memory\[8\]\[3\] sky130_fd_sc_hd__dfxtp_1
X_3079_ _0739_ _0743_ _0612_ VGND VGND VPWR VPWR _0744_ sky130_fd_sc_hd__o21a_1
XFILLER_0_49_222 VGND VGND VPWR VPWR sky130_fd_sc_hd__fill_2
XFILLER_0_9_352 VPWR VGND VPWR VGND sky130_ef_sc_hd__decap_12
XFILLER_0_32_111 VGND VGND VPWR VPWR sky130_fd_sc_hd__fill_1
XTAP_TAPCELL_ROW_88_721 VGND VPWR sky130_fd_sc_hd__tapvpwrvgnd_1
XFILLER_0_70_217 VGND VGND VPWR VPWR sky130_fd_sc_hd__fill_2
XFILLER_0_55_236 VGND VGND VPWR VPWR sky130_fd_sc_hd__fill_1
XFILLER_0_11_67 VGND VGND VPWR VPWR sky130_fd_sc_hd__fill_2
XFILLER_0_23_100 VGND VGND VPWR VPWR sky130_fd_sc_hd__fill_1
X_4120_ _1755_ _1765_ _1704_ VGND VGND VPWR VPWR _1766_ sky130_fd_sc_hd__mux2_1
X_4051_ _1670_ VGND VGND VPWR VPWR _1697_ sky130_fd_sc_hd__buf_2
X_3002_ _0537_ _0660_ VGND VGND VPWR VPWR _0667_ sky130_fd_sc_hd__or2_1
X_4953_ _2456_ VGND VGND VPWR VPWR _0131_ sky130_fd_sc_hd__clkbuf_1
XFILLER_0_52_85 VPWR VGND VPWR VGND sky130_ef_sc_hd__decap_12
X_4884_ _2401_ reg_file.memory\[4\]\[0\] _2409_ VGND VGND VPWR VPWR _2410_ sky130_fd_sc_hd__mux2_1
X_3904_ _1551_ _1559_ VGND VGND VPWR VPWR _1560_ sky130_fd_sc_hd__xor2_1
X_5505_ _2750_ VGND VGND VPWR VPWR _0389_ sky130_fd_sc_hd__clkbuf_1
X_5436_ _2455_ reg_file.memory\[15\]\[22\] _2713_ VGND VGND VPWR VPWR _2716_ sky130_fd_sc_hd__mux2_1
XFILLER_0_46_269 VGND VGND VPWR VPWR sky130_fd_sc_hd__fill_1
X_3697_ alu.ALUResult\[1\] seven_seg_conv.temp\[1\] _1352_ VGND VGND VPWR VPWR _1353_
+ sky130_fd_sc_hd__mux2_1
X_3835_ _1482_ _1490_ VGND VGND VPWR VPWR _1491_ sky130_fd_sc_hd__xor2_1
X_3766_ _1413_ _1421_ VGND VGND VPWR VPWR _1422_ sky130_fd_sc_hd__and2_1
XTAP_TAPCELL_ROW_85_702 VGND VPWR sky130_fd_sc_hd__tapvpwrvgnd_1
X_4249_ _1786_ _1713_ VGND VGND VPWR VPWR _1893_ sky130_fd_sc_hd__nor2_1
X_4318_ _1959_ VGND VGND VPWR VPWR _0531_ sky130_fd_sc_hd__clkbuf_1
X_5367_ reg_file.memory\[10\]\[22\] alu.ALUResult\[22\] _2676_ VGND VGND VPWR VPWR
+ _2679_ sky130_fd_sc_hd__mux2_1
X_5298_ _2642_ VGND VGND VPWR VPWR _0290_ sky130_fd_sc_hd__clkbuf_1
XFILLER_0_87_136 VGND VGND VPWR VPWR sky130_fd_sc_hd__fill_2
XFILLER_0_7_119 VGND VGND VPWR VPWR sky130_fd_sc_hd__fill_2
XFILLER_0_51_272 VGND VGND VPWR VPWR sky130_fd_sc_hd__fill_1
X_3620_ _1030_ _1195_ VGND VGND VPWR VPWR _1285_ sky130_fd_sc_hd__nand2_1
X_3551_ _0901_ _1213_ _1215_ VGND VGND VPWR VPWR _1216_ sky130_fd_sc_hd__a21oi_1
X_4103_ _1746_ _1748_ VGND VGND VPWR VPWR _1749_ sky130_fd_sc_hd__nand2_1
X_3482_ reg_file.memory\[5\]\[1\] _1146_ _0644_ VGND VGND VPWR VPWR _1147_ sky130_fd_sc_hd__mux2_1
X_5221_ _2603_ VGND VGND VPWR VPWR _0252_ sky130_fd_sc_hd__clkbuf_1
X_5152_ _2442_ reg_file.memory\[7\]\[16\] _2559_ VGND VGND VPWR VPWR _2566_ sky130_fd_sc_hd__mux2_1
X_4034_ _0821_ _1670_ VGND VGND VPWR VPWR _1680_ sky130_fd_sc_hd__nand2_1
XTAP_TAPCELL_ROW_47_470 VGND VPWR sky130_fd_sc_hd__tapvpwrvgnd_1
XTAP_TAPCELL_ROW_39_426 VGND VPWR sky130_fd_sc_hd__tapvpwrvgnd_1
X_5083_ _2529_ VGND VGND VPWR VPWR _0188_ sky130_fd_sc_hd__clkbuf_1
X_4867_ _2397_ VGND VGND VPWR VPWR _0104_ sky130_fd_sc_hd__clkbuf_1
X_3818_ _1465_ _1473_ VGND VGND VPWR VPWR _1474_ sky130_fd_sc_hd__xor2_1
X_4936_ _2444_ reg_file.memory\[4\]\[17\] _2430_ VGND VGND VPWR VPWR _2445_ sky130_fd_sc_hd__mux2_1
X_5985_ clknet_leaf_21_clk _0220_ VGND VGND VPWR VPWR reg_file.memory\[7\]\[15\] sky130_fd_sc_hd__dfxtp_1
XTAP_TAPCELL_ROW_30_370 VGND VPWR sky130_fd_sc_hd__tapvpwrvgnd_1
X_3749_ _1393_ _1394_ VGND VGND VPWR VPWR _1405_ sky130_fd_sc_hd__nor2_1
X_5419_ _2438_ reg_file.memory\[15\]\[14\] _2702_ VGND VGND VPWR VPWR _2707_ sky130_fd_sc_hd__mux2_1
XFILLER_0_6_163 VGND VGND VPWR VPWR sky130_fd_sc_hd__fill_1
X_4798_ _1413_ _1415_ VGND VGND VPWR VPWR _2363_ sky130_fd_sc_hd__nand2_1
XFILLER_0_84_139 VGND VGND VPWR VPWR sky130_fd_sc_hd__fill_1
XFILLER_0_69_158 VGND VGND VPWR VPWR sky130_fd_sc_hd__fill_1
XFILLER_0_48_309 VGND VGND VPWR VPWR sky130_fd_sc_hd__fill_2
XTAP_TAPCELL_ROW_36_407 VGND VPWR sky130_fd_sc_hd__tapvpwrvgnd_1
XFILLER_0_90_109 VGND VGND VPWR VPWR sky130_fd_sc_hd__decap_3
X_4721_ clk_div.counter\[8\] _2316_ VGND VGND VPWR VPWR _0037_ sky130_fd_sc_hd__xor2_1
XFILLER_0_75_139 VPWR VGND VPWR VGND sky130_ef_sc_hd__decap_12
XFILLER_0_68_180 VGND VGND VPWR VPWR sky130_fd_sc_hd__decap_4
X_4652_ _2089_ _2267_ _2268_ _1952_ VGND VGND VPWR VPWR _2269_ sky130_fd_sc_hd__o31a_1
X_5770_ clk_div.slow_clk _0053_ VGND VGND VPWR VPWR seven_seg_conv.temp\[6\] sky130_fd_sc_hd__dfxtp_1
X_2982_ _0646_ VGND VGND VPWR VPWR _0647_ sky130_fd_sc_hd__clkbuf_4
XFILLER_0_16_206 VGND VGND VPWR VPWR sky130_fd_sc_hd__fill_2
X_3465_ reg_file.memory\[5\]\[2\] _1129_ _0644_ VGND VGND VPWR VPWR _1130_ sky130_fd_sc_hd__mux2_1
X_6253_ clknet_leaf_12_clk _0488_ VGND VGND VPWR VPWR reg_file.memory\[2\]\[27\] sky130_fd_sc_hd__dfxtp_1
X_3603_ _0755_ _0756_ VGND VGND VPWR VPWR _1268_ sky130_fd_sc_hd__or2_1
X_4583_ _2198_ _2199_ _2205_ VGND VGND VPWR VPWR _0520_ sky130_fd_sc_hd__o21ai_1
X_3534_ _0990_ _0997_ VGND VGND VPWR VPWR _1199_ sky130_fd_sc_hd__or2_1
XFILLER_0_3_122 VGND VGND VPWR VPWR sky130_fd_sc_hd__fill_2
X_6184_ clknet_leaf_14_clk _0419_ VGND VGND VPWR VPWR reg_file.memory\[21\]\[22\]
+ sky130_fd_sc_hd__dfxtp_1
X_5135_ _2425_ reg_file.memory\[7\]\[8\] _2548_ VGND VGND VPWR VPWR _2557_ sky130_fd_sc_hd__mux2_1
X_5066_ _2520_ VGND VGND VPWR VPWR _0180_ sky130_fd_sc_hd__clkbuf_1
X_5204_ _2594_ VGND VGND VPWR VPWR _0244_ sky130_fd_sc_hd__clkbuf_1
X_3396_ _1060_ reg_file.memory\[10\]\[6\] _0645_ VGND VGND VPWR VPWR _1061_ sky130_fd_sc_hd__mux2_1
XFILLER_0_74_94 VPWR VGND VPWR VGND sky130_ef_sc_hd__decap_12
X_5968_ clknet_leaf_11_clk _0203_ VGND VGND VPWR VPWR reg_file.memory\[6\]\[30\] sky130_fd_sc_hd__dfxtp_1
XFILLER_0_66_128 VGND VGND VPWR VPWR sky130_fd_sc_hd__decap_3
X_4017_ _1660_ _1661_ _1662_ VGND VGND VPWR VPWR _1663_ sky130_fd_sc_hd__and3_1
XFILLER_0_74_194 VGND VGND VPWR VPWR sky130_fd_sc_hd__fill_2
X_5899_ clknet_leaf_11_clk _0134_ VGND VGND VPWR VPWR reg_file.memory\[4\]\[25\] sky130_fd_sc_hd__dfxtp_1
X_4919_ _2433_ VGND VGND VPWR VPWR _0120_ sky130_fd_sc_hd__clkbuf_1
XFILLER_0_57_117 VGND VGND VPWR VPWR sky130_fd_sc_hd__fill_1
XFILLER_0_80_153 VGND VGND VPWR VPWR sky130_fd_sc_hd__decap_3
XFILLER_0_0_136 VGND VGND VPWR VPWR sky130_fd_sc_hd__decap_4
X_3181_ reg_file.memory\[21\]\[19\] _0545_ _0625_ _0845_ VGND VGND VPWR VPWR _0846_
+ sky130_fd_sc_hd__o211ai_2
XFILLER_0_0_169 VGND VGND VPWR VPWR sky130_fd_sc_hd__fill_1
X_3250_ reg_file.memory\[8\]\[15\] reg_file.memory\[9\]\[15\] _0638_ VGND VGND VPWR
+ VPWR _0915_ sky130_fd_sc_hd__mux2_1
X_5822_ _0525_ _0014_ VGND VGND VPWR VPWR alu.ALUResult\[28\] sky130_fd_sc_hd__dlxtn_2
XFILLER_0_44_53 VGND VGND VPWR VPWR sky130_fd_sc_hd__fill_2
X_4704_ _2307_ VGND VGND VPWR VPWR _0031_ sky130_fd_sc_hd__clkbuf_1
X_5753_ clknet_leaf_6_clk _0037_ VGND VGND VPWR VPWR clk_div.counter\[8\] sky130_fd_sc_hd__dfxtp_1
X_2896_ _0539_ _0555_ VGND VGND VPWR VPWR _0561_ sky130_fd_sc_hd__nor2_1
XFILLER_0_71_175 VGND VGND VPWR VPWR sky130_fd_sc_hd__fill_1
XFILLER_0_71_164 VGND VGND VPWR VPWR sky130_fd_sc_hd__fill_1
X_2965_ _0537_ _0557_ VGND VGND VPWR VPWR _0630_ sky130_fd_sc_hd__nand2_1
X_4635_ _1321_ _2059_ VGND VGND VPWR VPWR _2253_ sky130_fd_sc_hd__nor2_1
XFILLER_0_60_85 VGND VGND VPWR VPWR sky130_fd_sc_hd__decap_4
XFILLER_0_60_74 VGND VGND VPWR VPWR sky130_fd_sc_hd__decap_8
XFILLER_0_29_353 VGND VGND VPWR VPWR sky130_fd_sc_hd__fill_2
X_5684_ reg_file.memory\[2\]\[13\] VGND VGND VPWR VPWR _2845_ sky130_fd_sc_hd__clkbuf_1
X_4566_ _1677_ _1681_ VGND VGND VPWR VPWR _2190_ sky130_fd_sc_hd__and2_1
X_4497_ _2101_ _2126_ _1719_ VGND VGND VPWR VPWR _2127_ sky130_fd_sc_hd__mux2_1
X_3517_ _1091_ _1098_ VGND VGND VPWR VPWR _1182_ sky130_fd_sc_hd__xnor2_2
X_3448_ _1109_ _1112_ VGND VGND VPWR VPWR _1113_ sky130_fd_sc_hd__nand2_1
X_6236_ clknet_leaf_23_clk _0471_ VGND VGND VPWR VPWR reg_file.memory\[2\]\[10\] sky130_fd_sc_hd__dfxtp_1
XFILLER_0_12_242 VGND VGND VPWR VPWR sky130_fd_sc_hd__fill_1
XFILLER_0_85_93 VPWR VGND VPWR VGND sky130_ef_sc_hd__decap_12
X_5049_ _1342_ _2407_ _2510_ VGND VGND VPWR VPWR _2511_ sky130_fd_sc_hd__or3_4
X_6098_ clknet_leaf_3_clk _0333_ VGND VGND VPWR VPWR reg_file.memory\[15\]\[0\] sky130_fd_sc_hd__dfxtp_1
X_6167_ clknet_leaf_1_clk _0402_ VGND VGND VPWR VPWR reg_file.memory\[21\]\[5\] sky130_fd_sc_hd__dfxtp_1
X_5118_ _2547_ VGND VGND VPWR VPWR _2548_ sky130_fd_sc_hd__clkbuf_4
X_3379_ _1041_ _1043_ _0663_ VGND VGND VPWR VPWR _1044_ sky130_fd_sc_hd__mux2_1
XFILLER_0_62_197 VGND VGND VPWR VPWR sky130_fd_sc_hd__decap_8
XFILLER_0_62_153 VPWR VGND VPWR VGND sky130_ef_sc_hd__decap_12
XFILLER_0_14_45 VGND VGND VPWR VPWR sky130_fd_sc_hd__fill_1
XFILLER_0_85_278 VGND VGND VPWR VPWR sky130_fd_sc_hd__fill_2
XFILLER_0_26_312 VGND VGND VPWR VPWR sky130_fd_sc_hd__fill_1
X_4351_ _1657_ _1990_ VGND VGND VPWR VPWR _1991_ sky130_fd_sc_hd__nor2_1
X_4282_ _1833_ _1834_ VGND VGND VPWR VPWR _1925_ sky130_fd_sc_hd__nand2_1
X_4420_ _1284_ _1994_ _2046_ _2055_ VGND VGND VPWR VPWR _0506_ sky130_fd_sc_hd__a211o_1
XFILLER_0_30_88 VGND VGND VPWR VPWR sky130_fd_sc_hd__fill_1
X_3302_ reg_file.memory\[2\]\[11\] _0566_ _0572_ reg_file.memory\[7\]\[11\] _0579_
+ VGND VGND VPWR VPWR _0967_ sky130_fd_sc_hd__o221a_1
XTAP_TAPCELL_ROW_69_605 VGND VPWR sky130_fd_sc_hd__tapvpwrvgnd_1
X_3095_ _0601_ _0759_ VGND VGND VPWR VPWR _0760_ sky130_fd_sc_hd__or2_1
XFILLER_0_55_85 VPWR VGND VPWR VGND sky130_ef_sc_hd__decap_12
X_3164_ reg_file.memory\[15\]\[20\] _0553_ _0617_ _0828_ VGND VGND VPWR VPWR _0829_
+ sky130_fd_sc_hd__a211o_1
X_3233_ _0897_ reg_file.memory\[10\]\[16\] _0647_ VGND VGND VPWR VPWR _0898_ sky130_fd_sc_hd__mux2_1
X_6021_ clknet_leaf_18_clk _0256_ VGND VGND VPWR VPWR reg_file.memory\[8\]\[19\] sky130_fd_sc_hd__dfxtp_1
XTAP_TAPCELL_ROW_52_505 VGND VPWR sky130_fd_sc_hd__tapvpwrvgnd_1
X_5805_ _0507_ _0014_ VGND VGND VPWR VPWR alu.ALUResult\[11\] sky130_fd_sc_hd__dlxtn_1
X_3997_ _1644_ _1645_ _1646_ VGND VGND VPWR VPWR _1647_ sky130_fd_sc_hd__mux2_1
XTAP_TAPCELL_ROW_17_292 VGND VPWR sky130_fd_sc_hd__tapvpwrvgnd_1
X_5736_ _0546_ _1331_ VGND VGND VPWR VPWR _0502_ sky130_fd_sc_hd__nand2_1
X_2948_ _0582_ _0608_ _0612_ VGND VGND VPWR VPWR _0613_ sky130_fd_sc_hd__o21a_1
X_4618_ _1976_ _2052_ _2237_ _2041_ VGND VGND VPWR VPWR _2238_ sky130_fd_sc_hd__o211a_1
X_2879_ _0543_ VGND VGND VPWR VPWR _0544_ sky130_fd_sc_hd__buf_4
X_5598_ _2415_ reg_file.memory\[25\]\[3\] _2797_ VGND VGND VPWR VPWR _2801_ sky130_fd_sc_hd__mux2_1
X_5667_ _2836_ VGND VGND VPWR VPWR _0465_ sky130_fd_sc_hd__clkbuf_1
XFILLER_0_32_337 VGND VGND VPWR VPWR sky130_fd_sc_hd__fill_2
XFILLER_0_4_272 VGND VGND VPWR VPWR sky130_fd_sc_hd__decap_6
X_6219_ clknet_leaf_8_clk _0454_ VGND VGND VPWR VPWR reg_file.memory\[25\]\[25\] sky130_fd_sc_hd__dfxtp_1
X_4549_ _1312_ _1954_ _1797_ _2174_ VGND VGND VPWR VPWR _2175_ sky130_fd_sc_hd__a22oi_1
XFILLER_0_67_278 VGND VGND VPWR VPWR sky130_fd_sc_hd__fill_2
XFILLER_0_67_245 VGND VGND VPWR VPWR sky130_fd_sc_hd__fill_2
XTAP_TAPCELL_ROW_0_193 VGND VPWR sky130_fd_sc_hd__tapvpwrvgnd_1
XTAP_TAPCELL_ROW_0_182 VGND VPWR sky130_fd_sc_hd__tapvpwrvgnd_1
Xclkload19 clknet_leaf_6_clk VGND VGND VPWR VPWR clkload19/Y sky130_fd_sc_hd__clkinvlp_4
XFILLER_0_50_156 VGND VGND VPWR VPWR sky130_fd_sc_hd__decap_4
X_3851_ _1504_ _1506_ _1502_ VGND VGND VPWR VPWR _1507_ sky130_fd_sc_hd__a21oi_1
X_3920_ _1562_ _1566_ VGND VGND VPWR VPWR _1576_ sky130_fd_sc_hd__nand2_1
X_5521_ _2758_ VGND VGND VPWR VPWR _2759_ sky130_fd_sc_hd__buf_2
X_5452_ _2471_ reg_file.memory\[15\]\[30\] _2690_ VGND VGND VPWR VPWR _2724_ sky130_fd_sc_hd__mux2_1
XFILLER_0_41_54 VGND VGND VPWR VPWR sky130_fd_sc_hd__fill_2
XTAP_TAPCELL_ROW_14_273 VGND VPWR sky130_fd_sc_hd__tapvpwrvgnd_1
X_3782_ _1369_ _1434_ VGND VGND VPWR VPWR _1438_ sky130_fd_sc_hd__nor2_1
X_4334_ _1738_ _1950_ _1828_ _1974_ _1845_ VGND VGND VPWR VPWR _1975_ sky130_fd_sc_hd__a32o_1
X_5383_ reg_file.memory\[10\]\[30\] _1376_ _2653_ VGND VGND VPWR VPWR _2687_ sky130_fd_sc_hd__mux2_1
X_4265_ _1703_ _1137_ _1904_ VGND VGND VPWR VPWR _1908_ sky130_fd_sc_hd__o21ai_1
X_4403_ _1744_ _2038_ _2039_ VGND VGND VPWR VPWR _2040_ sky130_fd_sc_hd__or3b_1
X_6004_ clknet_leaf_27_clk _0239_ VGND VGND VPWR VPWR reg_file.memory\[8\]\[2\] sky130_fd_sc_hd__dfxtp_1
XFILLER_0_82_61 VGND VGND VPWR VPWR sky130_fd_sc_hd__decap_4
X_3078_ _0575_ _0740_ _0742_ _0607_ VGND VGND VPWR VPWR _0743_ sky130_fd_sc_hd__o211a_1
X_4196_ _1675_ _1776_ VGND VGND VPWR VPWR _1841_ sky130_fd_sc_hd__nand2_1
X_3147_ _0807_ _0811_ _0612_ VGND VGND VPWR VPWR _0812_ sky130_fd_sc_hd__o21a_1
X_3216_ reg_file.memory\[8\]\[17\] reg_file.memory\[9\]\[17\] _0638_ VGND VGND VPWR
+ VPWR _0881_ sky130_fd_sc_hd__mux2_1
XPHY_EDGE_ROW_19_Left_110 VGND VGND VPWR VPWR sky130_fd_sc_hd__decap_3
X_5719_ _2862_ VGND VGND VPWR VPWR _0491_ sky130_fd_sc_hd__clkbuf_1
XFILLER_0_20_318 VGND VGND VPWR VPWR sky130_fd_sc_hd__fill_1
XFILLER_0_87_329 VGND VGND VPWR VPWR sky130_fd_sc_hd__fill_2
XTAP_TAPCELL_ROW_11_254 VGND VPWR sky130_fd_sc_hd__tapvpwrvgnd_1
XFILLER_0_11_318 VGND VGND VPWR VPWR sky130_fd_sc_hd__fill_2
X_3001_ _0657_ _0659_ _0665_ VGND VGND VPWR VPWR _0666_ sky130_fd_sc_hd__mux2_1
X_4050_ _1689_ _1695_ VGND VGND VPWR VPWR _1696_ sky130_fd_sc_hd__nand2_1
XFILLER_0_36_76 VGND VGND VPWR VPWR sky130_fd_sc_hd__fill_1
XFILLER_0_61_207 VGND VGND VPWR VPWR sky130_fd_sc_hd__decap_8
X_4952_ _2455_ reg_file.memory\[4\]\[22\] _2451_ VGND VGND VPWR VPWR _2456_ sky130_fd_sc_hd__mux2_1
XFILLER_0_52_97 VGND VGND VPWR VPWR sky130_fd_sc_hd__decap_6
X_4883_ _2408_ VGND VGND VPWR VPWR _2409_ sky130_fd_sc_hd__buf_4
X_3834_ _1487_ _1489_ _1483_ VGND VGND VPWR VPWR _1490_ sky130_fd_sc_hd__a21oi_1
XFILLER_0_6_323 VPWR VGND VPWR VGND sky130_ef_sc_hd__decap_12
X_3903_ _1556_ _1558_ _1552_ VGND VGND VPWR VPWR _1559_ sky130_fd_sc_hd__a21oi_1
X_3696_ _1351_ VGND VGND VPWR VPWR _1352_ sky130_fd_sc_hd__clkbuf_8
X_5504_ reg_file.memory\[1\]\[24\] VGND VGND VPWR VPWR _2750_ sky130_fd_sc_hd__clkbuf_1
XFILLER_0_65_3 VGND VGND VPWR VPWR sky130_fd_sc_hd__decap_8
X_5435_ _2715_ VGND VGND VPWR VPWR _0354_ sky130_fd_sc_hd__clkbuf_1
X_3765_ _1420_ _1415_ _1412_ _1410_ VGND VGND VPWR VPWR _1421_ sky130_fd_sc_hd__o211ai_1
X_4248_ _1890_ _1891_ _1704_ VGND VGND VPWR VPWR _1892_ sky130_fd_sc_hd__mux2_1
XTAP_TAPCELL_ROW_85_703 VGND VPWR sky130_fd_sc_hd__tapvpwrvgnd_1
X_4317_ _1953_ _1958_ VGND VGND VPWR VPWR _1959_ sky130_fd_sc_hd__or2_1
X_5297_ reg_file.memory\[0\]\[21\] VGND VGND VPWR VPWR _2642_ sky130_fd_sc_hd__clkbuf_1
X_5366_ _2678_ VGND VGND VPWR VPWR _0322_ sky130_fd_sc_hd__clkbuf_1
XTAP_TAPCELL_ROW_2_200 VGND VPWR sky130_fd_sc_hd__tapvpwrvgnd_1
XFILLER_0_10_362 VGND VGND VPWR VPWR sky130_fd_sc_hd__fill_2
X_4179_ _1710_ _1711_ VGND VGND VPWR VPWR _1824_ sky130_fd_sc_hd__or2_1
XFILLER_0_77_362 VGND VGND VPWR VPWR sky130_fd_sc_hd__fill_2
XFILLER_0_37_248 VGND VGND VPWR VPWR sky130_fd_sc_hd__decap_3
XTAP_TAPCELL_ROW_33_390 VGND VPWR sky130_fd_sc_hd__tapvpwrvgnd_1
XPHY_EDGE_ROW_14_Right_14 VGND VGND VPWR VPWR sky130_fd_sc_hd__decap_3
XPHY_EDGE_ROW_23_Right_23 VGND VGND VPWR VPWR sky130_fd_sc_hd__decap_3
XFILLER_0_73_19 VGND VGND VPWR VPWR sky130_fd_sc_hd__fill_2
XPHY_EDGE_ROW_32_Right_32 VGND VGND VPWR VPWR sky130_fd_sc_hd__decap_3
X_3481_ reg_file.memory\[6\]\[1\] reg_file.memory\[7\]\[1\] _0635_ VGND VGND VPWR
+ VPWR _1146_ sky130_fd_sc_hd__mux2_1
X_3550_ _0885_ _1214_ VGND VGND VPWR VPWR _1215_ sky130_fd_sc_hd__or2_1
X_5220_ reg_file.memory\[8\]\[15\] alu.ALUResult\[15\] _2597_ VGND VGND VPWR VPWR
+ _2603_ sky130_fd_sc_hd__mux2_1
X_4033_ _1165_ VGND VGND VPWR VPWR _1679_ sky130_fd_sc_hd__buf_2
X_4102_ _1675_ _1747_ VGND VGND VPWR VPWR _1748_ sky130_fd_sc_hd__nand2_1
XFILLER_0_47_31 VGND VGND VPWR VPWR sky130_fd_sc_hd__decap_8
XPHY_EDGE_ROW_41_Right_41 VGND VGND VPWR VPWR sky130_fd_sc_hd__decap_3
X_5082_ _2440_ reg_file.memory\[6\]\[15\] _2523_ VGND VGND VPWR VPWR _2529_ sky130_fd_sc_hd__mux2_1
X_5151_ _2565_ VGND VGND VPWR VPWR _0220_ sky130_fd_sc_hd__clkbuf_1
XFILLER_0_63_96 VPWR VGND VPWR VGND sky130_ef_sc_hd__decap_12
XPHY_EDGE_ROW_50_Right_50 VGND VGND VPWR VPWR sky130_fd_sc_hd__decap_3
XTAP_TAPCELL_ROW_47_471 VGND VPWR sky130_fd_sc_hd__tapvpwrvgnd_1
XTAP_TAPCELL_ROW_39_427 VGND VPWR sky130_fd_sc_hd__tapvpwrvgnd_1
X_5984_ clknet_leaf_21_clk _0219_ VGND VGND VPWR VPWR reg_file.memory\[7\]\[14\] sky130_fd_sc_hd__dfxtp_1
X_4866_ reg_file.memory\[9\]\[28\] VGND VGND VPWR VPWR _2397_ sky130_fd_sc_hd__clkbuf_1
XFILLER_0_42_240 VGND VGND VPWR VPWR sky130_fd_sc_hd__fill_1
XTAP_TAPCELL_ROW_30_371 VGND VPWR sky130_fd_sc_hd__tapvpwrvgnd_1
XFILLER_0_27_281 VGND VGND VPWR VPWR sky130_fd_sc_hd__fill_2
X_3748_ _1393_ _1400_ VGND VGND VPWR VPWR _1404_ sky130_fd_sc_hd__xnor2_1
X_3817_ _1467_ _1472_ _1468_ VGND VGND VPWR VPWR _1473_ sky130_fd_sc_hd__a21oi_1
X_4935_ alu.ALUResult\[17\] VGND VGND VPWR VPWR _2444_ sky130_fd_sc_hd__dlymetal6s2s_1
X_4797_ _2362_ VGND VGND VPWR VPWR _0069_ sky130_fd_sc_hd__clkbuf_1
X_3679_ _0537_ _0542_ ctrl_unit.PCWrite VGND VGND VPWR VPWR _1338_ sky130_fd_sc_hd__o21ba_1
X_5418_ _2706_ VGND VGND VPWR VPWR _0346_ sky130_fd_sc_hd__clkbuf_1
XFILLER_0_6_197 VPWR VGND VPWR VGND sky130_ef_sc_hd__decap_12
X_5349_ _2669_ VGND VGND VPWR VPWR _0314_ sky130_fd_sc_hd__clkbuf_1
XFILLER_0_80_324 VGND VGND VPWR VPWR sky130_fd_sc_hd__fill_1
XFILLER_0_0_307 VGND VGND VPWR VPWR sky130_fd_sc_hd__fill_1
XFILLER_0_84_29 VGND VGND VPWR VPWR sky130_fd_sc_hd__decap_4
XFILLER_0_75_118 VGND VGND VPWR VPWR sky130_fd_sc_hd__fill_1
XTAP_TAPCELL_ROW_36_408 VGND VPWR sky130_fd_sc_hd__tapvpwrvgnd_1
XFILLER_0_17_45 VGND VGND VPWR VPWR sky130_fd_sc_hd__fill_2
X_4720_ _2318_ VGND VGND VPWR VPWR _0036_ sky130_fd_sc_hd__clkbuf_1
XFILLER_0_83_151 VGND VGND VPWR VPWR sky130_fd_sc_hd__fill_1
XFILLER_0_68_170 VGND VGND VPWR VPWR sky130_fd_sc_hd__fill_1
X_4651_ _2071_ _2178_ _2130_ VGND VGND VPWR VPWR _2268_ sky130_fd_sc_hd__o21ai_1
X_3602_ _1232_ _1266_ VGND VGND VPWR VPWR _1267_ sky130_fd_sc_hd__and2_1
XTAP_TAPCELL_ROW_44_452 VGND VPWR sky130_fd_sc_hd__tapvpwrvgnd_1
X_2981_ _0645_ VGND VGND VPWR VPWR _0646_ sky130_fd_sc_hd__clkbuf_4
X_3464_ reg_file.memory\[6\]\[2\] reg_file.memory\[7\]\[2\] _0635_ VGND VGND VPWR
+ VPWR _1129_ sky130_fd_sc_hd__mux2_1
XFILLER_0_58_74 VGND VGND VPWR VPWR sky130_fd_sc_hd__fill_1
X_4582_ _1952_ _2204_ _1265_ _2059_ VGND VGND VPWR VPWR _2205_ sky130_fd_sc_hd__o2bb2a_1
X_3533_ _1030_ _1195_ _1197_ VGND VGND VPWR VPWR _1198_ sky130_fd_sc_hd__a21o_1
X_6183_ clknet_leaf_15_clk _0418_ VGND VGND VPWR VPWR reg_file.memory\[21\]\[21\]
+ sky130_fd_sc_hd__dfxtp_1
X_6252_ clknet_leaf_15_clk _0487_ VGND VGND VPWR VPWR reg_file.memory\[2\]\[26\] sky130_fd_sc_hd__dfxtp_1
X_5203_ reg_file.memory\[8\]\[7\] alu.ALUResult\[7\] _2586_ VGND VGND VPWR VPWR _2594_
+ sky130_fd_sc_hd__mux2_1
X_4016_ _0893_ _0911_ _0927_ _0943_ VGND VGND VPWR VPWR _1662_ sky130_fd_sc_hd__and4_1
X_5134_ _2556_ VGND VGND VPWR VPWR _0212_ sky130_fd_sc_hd__clkbuf_1
X_5065_ _2423_ reg_file.memory\[6\]\[7\] _2512_ VGND VGND VPWR VPWR _2520_ sky130_fd_sc_hd__mux2_1
X_3395_ reg_file.memory\[8\]\[6\] reg_file.memory\[9\]\[6\] _0636_ VGND VGND VPWR
+ VPWR _1060_ sky130_fd_sc_hd__mux2_1
X_5967_ clknet_leaf_10_clk _0202_ VGND VGND VPWR VPWR reg_file.memory\[6\]\[29\] sky130_fd_sc_hd__dfxtp_1
X_4918_ _2432_ reg_file.memory\[4\]\[11\] _2430_ VGND VGND VPWR VPWR _2433_ sky130_fd_sc_hd__mux2_1
X_5898_ clknet_leaf_11_clk _0133_ VGND VGND VPWR VPWR reg_file.memory\[4\]\[24\] sky130_fd_sc_hd__dfxtp_1
XTAP_TAPCELL_ROW_50_488 VGND VPWR sky130_fd_sc_hd__tapvpwrvgnd_1
X_4849_ _2388_ VGND VGND VPWR VPWR _0095_ sky130_fd_sc_hd__clkbuf_1
XFILLER_0_38_321 VGND VGND VPWR VPWR sky130_fd_sc_hd__fill_1
Xclkbuf_leaf_23_clk clknet_1_0__leaf_clk VGND VGND VPWR VPWR clknet_leaf_23_clk sky130_fd_sc_hd__clkbuf_8
XFILLER_0_80_187 VGND VGND VPWR VPWR sky130_fd_sc_hd__decap_8
XFILLER_0_21_298 VGND VGND VPWR VPWR sky130_fd_sc_hd__decap_3
X_3180_ reg_file.memory\[15\]\[19\] _0553_ _0617_ _0844_ VGND VGND VPWR VPWR _0845_
+ sky130_fd_sc_hd__a211o_1
X_5752_ clknet_leaf_6_clk _0036_ VGND VGND VPWR VPWR clk_div.counter\[7\] sky130_fd_sc_hd__dfxtp_1
X_2964_ _0540_ _0628_ _0548_ VGND VGND VPWR VPWR _0629_ sky130_fd_sc_hd__a21o_1
X_5821_ _0524_ _0014_ VGND VGND VPWR VPWR alu.ALUResult\[27\] sky130_fd_sc_hd__dlxtn_1
X_4703_ _2302_ _2305_ _2306_ VGND VGND VPWR VPWR _2307_ sky130_fd_sc_hd__and3_1
X_2895_ _0559_ VGND VGND VPWR VPWR _0560_ sky130_fd_sc_hd__inv_2
Xclkbuf_leaf_14_clk clknet_1_1__leaf_clk VGND VGND VPWR VPWR clknet_leaf_14_clk sky130_fd_sc_hd__clkbuf_8
X_4634_ _2077_ _2250_ _2251_ _2075_ _2001_ VGND VGND VPWR VPWR _2252_ sky130_fd_sc_hd__o32a_1
XFILLER_0_56_195 VGND VGND VPWR VPWR sky130_fd_sc_hd__fill_1
X_4565_ _2187_ _2188_ _1999_ VGND VGND VPWR VPWR _2189_ sky130_fd_sc_hd__and3b_1
X_5683_ _2844_ VGND VGND VPWR VPWR _0473_ sky130_fd_sc_hd__clkbuf_1
XFILLER_0_8_65 VGND VGND VPWR VPWR sky130_fd_sc_hd__decap_4
X_4496_ _1699_ _1746_ VGND VGND VPWR VPWR _2126_ sky130_fd_sc_hd__nand2_1
X_3516_ _1108_ _1119_ _1180_ VGND VGND VPWR VPWR _1181_ sky130_fd_sc_hd__a21o_1
X_3447_ reg_file.memory\[0\]\[3\] _1111_ _0654_ VGND VGND VPWR VPWR _1112_ sky130_fd_sc_hd__mux2_1
X_6166_ clknet_leaf_1_clk _0401_ VGND VGND VPWR VPWR reg_file.memory\[21\]\[4\] sky130_fd_sc_hd__dfxtp_1
X_6235_ clknet_leaf_23_clk _0470_ VGND VGND VPWR VPWR reg_file.memory\[2\]\[9\] sky130_fd_sc_hd__dfxtp_1
XPHY_EDGE_ROW_4_Right_4 VGND VGND VPWR VPWR sky130_fd_sc_hd__decap_3
X_3378_ _1042_ reg_file.memory\[10\]\[7\] _0645_ VGND VGND VPWR VPWR _1043_ sky130_fd_sc_hd__mux2_1
X_5117_ _2402_ _1342_ _2404_ _2407_ VGND VGND VPWR VPWR _2547_ sky130_fd_sc_hd__or4_4
X_5048_ _1334_ _2404_ VGND VGND VPWR VPWR _2510_ sky130_fd_sc_hd__nand2_1
X_6097_ clknet_leaf_14_clk _0332_ VGND VGND VPWR VPWR reg_file.memory\[10\]\[31\]
+ sky130_fd_sc_hd__dfxtp_1
XFILLER_0_62_187 VGND VGND VPWR VPWR sky130_fd_sc_hd__decap_8
XFILLER_0_62_165 VPWR VGND VPWR VGND sky130_ef_sc_hd__decap_12
XFILLER_0_85_257 VGND VGND VPWR VPWR sky130_fd_sc_hd__fill_1
XFILLER_0_85_202 VPWR VGND VPWR VGND sky130_ef_sc_hd__decap_12
X_4350_ _1890_ _1895_ _1767_ VGND VGND VPWR VPWR _1990_ sky130_fd_sc_hd__mux2_1
XTAP_TAPCELL_ROW_69_606 VGND VPWR sky130_fd_sc_hd__tapvpwrvgnd_1
X_4281_ _1107_ _1741_ VGND VGND VPWR VPWR _1924_ sky130_fd_sc_hd__or2_1
Xclkbuf_leaf_3_clk clknet_1_1__leaf_clk VGND VGND VPWR VPWR clknet_leaf_3_clk sky130_fd_sc_hd__clkbuf_8
X_3301_ reg_file.memory\[25\]\[12\] _0965_ _0669_ VGND VGND VPWR VPWR _0966_ sky130_fd_sc_hd__mux2_2
X_3232_ reg_file.memory\[8\]\[16\] reg_file.memory\[9\]\[16\] _0638_ VGND VGND VPWR
+ VPWR _0897_ sky130_fd_sc_hd__mux2_1
X_6020_ clknet_leaf_18_clk _0255_ VGND VGND VPWR VPWR reg_file.memory\[8\]\[18\] sky130_fd_sc_hd__dfxtp_1
XTAP_TAPCELL_ROW_77_650 VGND VPWR sky130_fd_sc_hd__tapvpwrvgnd_1
X_3094_ reg_file.memory\[0\]\[24\] reg_file.memory\[1\]\[24\] _0595_ VGND VGND VPWR
+ VPWR _0759_ sky130_fd_sc_hd__mux2_1
X_3163_ _0823_ _0827_ _0611_ VGND VGND VPWR VPWR _0828_ sky130_fd_sc_hd__o21a_1
X_5735_ _2296_ net3 _1352_ VGND VGND VPWR VPWR _0501_ sky130_fd_sc_hd__o21a_1
XFILLER_0_76_279 VGND VGND VPWR VPWR sky130_fd_sc_hd__fill_2
XTAP_TAPCELL_ROW_60_550 VGND VPWR sky130_fd_sc_hd__tapvpwrvgnd_1
XFILLER_0_44_132 VGND VGND VPWR VPWR sky130_fd_sc_hd__fill_2
X_2947_ _0611_ VGND VGND VPWR VPWR _0612_ sky130_fd_sc_hd__clkbuf_4
X_5804_ _0506_ _0014_ VGND VGND VPWR VPWR alu.ALUResult\[10\] sky130_fd_sc_hd__dlxtn_1
X_3996_ _1636_ _1630_ VGND VGND VPWR VPWR _1646_ sky130_fd_sc_hd__xnor2_1
XTAP_TAPCELL_ROW_17_293 VGND VPWR sky130_fd_sc_hd__tapvpwrvgnd_1
XFILLER_0_17_335 VGND VGND VPWR VPWR sky130_fd_sc_hd__fill_1
X_2878_ _0538_ _0542_ VGND VGND VPWR VPWR _0543_ sky130_fd_sc_hd__nand2_2
X_4548_ _1951_ _2135_ _2173_ _1944_ _1800_ VGND VGND VPWR VPWR _2174_ sky130_fd_sc_hd__o32a_1
X_5597_ _2800_ VGND VGND VPWR VPWR _0431_ sky130_fd_sc_hd__clkbuf_1
X_4617_ _2047_ _2135_ _2236_ VGND VGND VPWR VPWR _2237_ sky130_fd_sc_hd__or3_1
X_5666_ reg_file.memory\[2\]\[4\] VGND VGND VPWR VPWR _2836_ sky130_fd_sc_hd__clkbuf_1
X_6218_ clknet_leaf_13_clk _0453_ VGND VGND VPWR VPWR reg_file.memory\[25\]\[24\]
+ sky130_fd_sc_hd__dfxtp_1
X_4479_ _2109_ _2097_ _1273_ VGND VGND VPWR VPWR _2110_ sky130_fd_sc_hd__o21a_1
X_6149_ clknet_leaf_17_clk _0384_ VGND VGND VPWR VPWR reg_file.memory\[1\]\[19\] sky130_fd_sc_hd__dfxtp_1
XTAP_TAPCELL_ROW_83_686 VGND VPWR sky130_fd_sc_hd__tapvpwrvgnd_1
XPHY_EDGE_ROW_79_Right_79 VGND VGND VPWR VPWR sky130_fd_sc_hd__decap_3
XTAP_TAPCELL_ROW_0_183 VGND VPWR sky130_fd_sc_hd__tapvpwrvgnd_1
XFILLER_0_90_293 VGND VGND VPWR VPWR sky130_fd_sc_hd__fill_2
XPHY_EDGE_ROW_88_Right_88 VGND VGND VPWR VPWR sky130_fd_sc_hd__decap_3
XFILLER_0_50_168 VGND VGND VPWR VPWR sky130_fd_sc_hd__fill_2
XFILLER_0_73_238 VGND VGND VPWR VPWR sky130_fd_sc_hd__decap_3
XFILLER_0_66_290 VGND VGND VPWR VPWR sky130_fd_sc_hd__fill_2
X_3850_ _1501_ _1505_ VGND VGND VPWR VPWR _1506_ sky130_fd_sc_hd__or2_2
X_3781_ _1368_ _1433_ _1436_ VGND VGND VPWR VPWR _1437_ sky130_fd_sc_hd__or3b_1
X_5382_ _2686_ VGND VGND VPWR VPWR _0330_ sky130_fd_sc_hd__clkbuf_1
X_5451_ _2723_ VGND VGND VPWR VPWR _0362_ sky130_fd_sc_hd__clkbuf_1
X_4402_ _1707_ _1815_ _1862_ _1889_ VGND VGND VPWR VPWR _2039_ sky130_fd_sc_hd__o22a_1
X_5520_ _1334_ _2404_ _2407_ _1342_ VGND VGND VPWR VPWR _2758_ sky130_fd_sc_hd__or4b_1
XFILLER_0_41_113 VGND VGND VPWR VPWR sky130_fd_sc_hd__decap_3
XTAP_TAPCELL_ROW_14_274 VGND VPWR sky130_fd_sc_hd__tapvpwrvgnd_1
X_4333_ _1973_ _1823_ _1816_ VGND VGND VPWR VPWR _1974_ sky130_fd_sc_hd__mux2_1
X_4195_ _1679_ _1769_ VGND VGND VPWR VPWR _1840_ sky130_fd_sc_hd__nand2_1
X_4264_ _1795_ VGND VGND VPWR VPWR _1907_ sky130_fd_sc_hd__clkbuf_4
X_3215_ reg_file.memory\[0\]\[17\] _0879_ _0655_ VGND VGND VPWR VPWR _0880_ sky130_fd_sc_hd__mux2_1
X_6003_ clknet_leaf_27_clk _0238_ VGND VGND VPWR VPWR reg_file.memory\[8\]\[1\] sky130_fd_sc_hd__dfxtp_1
X_3077_ _0600_ _0741_ VGND VGND VPWR VPWR _0742_ sky130_fd_sc_hd__or2_1
X_3146_ _0574_ _0808_ _0810_ _0607_ VGND VGND VPWR VPWR _0811_ sky130_fd_sc_hd__o211a_1
X_5718_ reg_file.memory\[2\]\[30\] VGND VGND VPWR VPWR _2862_ sky130_fd_sc_hd__clkbuf_1
XFILLER_0_49_279 VGND VGND VPWR VPWR sky130_fd_sc_hd__fill_1
XFILLER_0_32_124 VGND VGND VPWR VPWR sky130_fd_sc_hd__fill_2
X_3979_ _1344_ seven_seg_conv.current_digit\[3\] _1631_ _1632_ VGND VGND VPWR VPWR
+ _1633_ sky130_fd_sc_hd__a22o_1
X_5649_ _2827_ VGND VGND VPWR VPWR _0456_ sky130_fd_sc_hd__clkbuf_1
XFILLER_0_32_168 VGND VGND VPWR VPWR sky130_fd_sc_hd__fill_2
XFILLER_0_32_157 VGND VGND VPWR VPWR sky130_fd_sc_hd__fill_2
XTAP_TAPCELL_ROW_5_220 VGND VPWR sky130_fd_sc_hd__tapvpwrvgnd_1
XTAP_TAPCELL_ROW_11_255 VGND VPWR sky130_fd_sc_hd__tapvpwrvgnd_1
XFILLER_0_23_113 VGND VGND VPWR VPWR sky130_fd_sc_hd__fill_1
X_4951_ alu.ALUResult\[22\] VGND VGND VPWR VPWR _2455_ sky130_fd_sc_hd__dlymetal6s2s_1
X_3000_ _0664_ VGND VGND VPWR VPWR _0665_ sky130_fd_sc_hd__buf_4
X_4882_ _1342_ _2405_ _2407_ VGND VGND VPWR VPWR _2408_ sky130_fd_sc_hd__or3_4
X_3833_ _1488_ _1486_ VGND VGND VPWR VPWR _1489_ sky130_fd_sc_hd__or2b_1
XFILLER_0_6_335 VGND VGND VPWR VPWR sky130_fd_sc_hd__decap_6
X_3902_ _1545_ _1549_ _1557_ VGND VGND VPWR VPWR _1558_ sky130_fd_sc_hd__a21boi_2
X_3764_ _1371_ _1409_ VGND VGND VPWR VPWR _1420_ sky130_fd_sc_hd__and2_1
X_5503_ _2749_ VGND VGND VPWR VPWR _0388_ sky130_fd_sc_hd__clkbuf_1
X_3695_ _1344_ seven_seg_conv.digit_counter\[2\] seven_seg_conv.digit_counter\[0\]
+ seven_seg_conv.digit_counter\[1\] VGND VGND VPWR VPWR _1351_ sky130_fd_sc_hd__or4_4
X_5434_ _2453_ reg_file.memory\[15\]\[21\] _2713_ VGND VGND VPWR VPWR _2715_ sky130_fd_sc_hd__mux2_1
X_5365_ reg_file.memory\[10\]\[21\] alu.ALUResult\[21\] _2676_ VGND VGND VPWR VPWR
+ _2678_ sky130_fd_sc_hd__mux2_1
X_4247_ _1685_ _1694_ _1687_ VGND VGND VPWR VPWR _1891_ sky130_fd_sc_hd__mux2_1
X_4178_ _1779_ _1817_ _1818_ _1822_ VGND VGND VPWR VPWR _1823_ sky130_fd_sc_hd__a31o_1
X_4316_ _1292_ _1954_ _1795_ _1957_ VGND VGND VPWR VPWR _1958_ sky130_fd_sc_hd__a22o_1
X_5296_ _2641_ VGND VGND VPWR VPWR _0289_ sky130_fd_sc_hd__clkbuf_1
XTAP_TAPCELL_ROW_2_201 VGND VPWR sky130_fd_sc_hd__tapvpwrvgnd_1
X_3129_ _0601_ _0793_ VGND VGND VPWR VPWR _0794_ sky130_fd_sc_hd__or2_1
XFILLER_0_52_219 VGND VGND VPWR VPWR sky130_fd_sc_hd__fill_1
XTAP_TAPCELL_ROW_33_391 VGND VPWR sky130_fd_sc_hd__tapvpwrvgnd_1
XPHY_EDGE_ROW_38_Left_129 VGND VGND VPWR VPWR sky130_fd_sc_hd__decap_3
X_3480_ _0577_ _0623_ _1144_ VGND VGND VPWR VPWR _1145_ sky130_fd_sc_hd__o21ai_2
XPHY_EDGE_ROW_47_Left_138 VGND VGND VPWR VPWR sky130_fd_sc_hd__decap_3
X_4032_ _1673_ _1677_ VGND VGND VPWR VPWR _1678_ sky130_fd_sc_hd__nand2_1
X_4101_ _0934_ _1670_ VGND VGND VPWR VPWR _1747_ sky130_fd_sc_hd__nand2_1
XFILLER_0_47_54 VGND VGND VPWR VPWR sky130_fd_sc_hd__fill_2
X_5081_ _2528_ VGND VGND VPWR VPWR _0187_ sky130_fd_sc_hd__clkbuf_1
X_5150_ _2440_ reg_file.memory\[7\]\[15\] _2559_ VGND VGND VPWR VPWR _2565_ sky130_fd_sc_hd__mux2_1
XFILLER_0_86_160 VGND VGND VPWR VPWR sky130_fd_sc_hd__decap_4
XFILLER_0_78_127 VPWR VGND VPWR VGND sky130_ef_sc_hd__decap_12
XFILLER_0_63_86 VGND VGND VPWR VPWR sky130_fd_sc_hd__fill_2
XFILLER_0_63_31 VGND VGND VPWR VPWR sky130_fd_sc_hd__fill_1
XFILLER_0_59_330 VGND VGND VPWR VPWR sky130_fd_sc_hd__fill_1
XPHY_EDGE_ROW_56_Left_147 VGND VGND VPWR VPWR sky130_fd_sc_hd__decap_3
XTAP_TAPCELL_ROW_47_472 VGND VPWR sky130_fd_sc_hd__tapvpwrvgnd_1
X_5983_ clknet_leaf_21_clk _0218_ VGND VGND VPWR VPWR reg_file.memory\[7\]\[13\] sky130_fd_sc_hd__dfxtp_1
X_4934_ _2443_ VGND VGND VPWR VPWR _0125_ sky130_fd_sc_hd__clkbuf_1
X_4865_ _2396_ VGND VGND VPWR VPWR _0103_ sky130_fd_sc_hd__clkbuf_1
XPHY_EDGE_ROW_65_Left_156 VGND VGND VPWR VPWR sky130_fd_sc_hd__decap_3
XTAP_TAPCELL_ROW_30_372 VGND VPWR sky130_fd_sc_hd__tapvpwrvgnd_1
X_3747_ _1372_ _1400_ _1402_ VGND VGND VPWR VPWR _1403_ sky130_fd_sc_hd__nor3_1
X_3816_ _1465_ _1468_ _1469_ _1471_ VGND VGND VPWR VPWR _1472_ sky130_fd_sc_hd__a2bb2o_1
XFILLER_0_6_187 VGND VGND VPWR VPWR sky130_fd_sc_hd__fill_2
X_4796_ seven_seg_conv.temp\[22\] _1429_ _1635_ VGND VGND VPWR VPWR _2362_ sky130_fd_sc_hd__mux2_1
X_3678_ _1337_ VGND VGND VPWR VPWR _0009_ sky130_fd_sc_hd__clkbuf_1
X_5417_ _2436_ reg_file.memory\[15\]\[13\] _2702_ VGND VGND VPWR VPWR _2706_ sky130_fd_sc_hd__mux2_1
X_5348_ reg_file.memory\[10\]\[13\] alu.ALUResult\[13\] _2665_ VGND VGND VPWR VPWR
+ _2669_ sky130_fd_sc_hd__mux2_1
XPHY_EDGE_ROW_74_Left_165 VGND VGND VPWR VPWR sky130_fd_sc_hd__decap_3
XFILLER_0_69_127 VGND VGND VPWR VPWR sky130_fd_sc_hd__fill_1
XFILLER_0_69_105 VGND VGND VPWR VPWR sky130_fd_sc_hd__fill_2
X_5279_ reg_file.memory\[0\]\[12\] VGND VGND VPWR VPWR _2633_ sky130_fd_sc_hd__clkbuf_1
XFILLER_0_65_322 VGND VGND VPWR VPWR sky130_fd_sc_hd__fill_2
XPHY_EDGE_ROW_83_Left_174 VGND VGND VPWR VPWR sky130_fd_sc_hd__decap_3
XFILLER_0_75_108 VGND VGND VPWR VPWR sky130_fd_sc_hd__decap_4
XTAP_TAPCELL_ROW_44_453 VGND VPWR sky130_fd_sc_hd__tapvpwrvgnd_1
XTAP_TAPCELL_ROW_36_409 VGND VPWR sky130_fd_sc_hd__tapvpwrvgnd_1
XPHY_EDGE_ROW_1_Left_92 VGND VGND VPWR VPWR sky130_fd_sc_hd__decap_3
XFILLER_0_17_57 VGND VGND VPWR VPWR sky130_fd_sc_hd__decap_4
X_2980_ _0644_ VGND VGND VPWR VPWR _0645_ sky130_fd_sc_hd__clkbuf_4
X_4650_ _1738_ _2224_ _2265_ _2266_ _1742_ VGND VGND VPWR VPWR _2267_ sky130_fd_sc_hd__o221a_1
X_4581_ _2004_ _2135_ _2203_ _2008_ _1800_ VGND VGND VPWR VPWR _2204_ sky130_fd_sc_hd__o32a_1
X_3601_ _1229_ _1230_ _1231_ VGND VGND VPWR VPWR _1266_ sky130_fd_sc_hd__or3_1
X_6251_ clknet_leaf_11_clk _0486_ VGND VGND VPWR VPWR reg_file.memory\[2\]\[25\] sky130_fd_sc_hd__dfxtp_1
X_3463_ _0597_ _0623_ _1127_ VGND VGND VPWR VPWR _1128_ sky130_fd_sc_hd__o21a_1
X_3532_ _1014_ _1196_ VGND VGND VPWR VPWR _1197_ sky130_fd_sc_hd__nand2_1
X_6182_ clknet_leaf_15_clk _0417_ VGND VGND VPWR VPWR reg_file.memory\[21\]\[20\]
+ sky130_fd_sc_hd__dfxtp_1
X_5133_ _2423_ reg_file.memory\[7\]\[7\] _2548_ VGND VGND VPWR VPWR _2556_ sky130_fd_sc_hd__mux2_1
X_5202_ _2593_ VGND VGND VPWR VPWR _0243_ sky130_fd_sc_hd__clkbuf_1
X_3394_ reg_file.memory\[0\]\[6\] _1058_ _0654_ VGND VGND VPWR VPWR _1059_ sky130_fd_sc_hd__mux2_1
X_4015_ _0959_ _0974_ _0990_ _1006_ VGND VGND VPWR VPWR _1661_ sky130_fd_sc_hd__and4_1
X_5064_ _2519_ VGND VGND VPWR VPWR _0179_ sky130_fd_sc_hd__clkbuf_1
XFILLER_0_90_62 VGND VGND VPWR VPWR sky130_fd_sc_hd__fill_2
X_5897_ clknet_leaf_10_clk _0132_ VGND VGND VPWR VPWR reg_file.memory\[4\]\[23\] sky130_fd_sc_hd__dfxtp_1
X_5966_ clknet_leaf_9_clk _0201_ VGND VGND VPWR VPWR reg_file.memory\[6\]\[28\] sky130_fd_sc_hd__dfxtp_1
XFILLER_0_74_152 VPWR VGND VPWR VGND sky130_ef_sc_hd__decap_12
XFILLER_0_74_130 VGND VGND VPWR VPWR sky130_fd_sc_hd__decap_8
X_4917_ alu.ALUResult\[11\] VGND VGND VPWR VPWR _2432_ sky130_fd_sc_hd__dlymetal6s2s_1
X_4848_ reg_file.memory\[9\]\[19\] VGND VGND VPWR VPWR _2388_ sky130_fd_sc_hd__clkbuf_1
XTAP_TAPCELL_ROW_50_489 VGND VPWR sky130_fd_sc_hd__tapvpwrvgnd_1
X_4779_ seven_seg_conv.temp\[14\] _1497_ _2334_ VGND VGND VPWR VPWR _2353_ sky130_fd_sc_hd__mux2_1
XTAP_TAPCELL_ROW_41_434 VGND VPWR sky130_fd_sc_hd__tapvpwrvgnd_1
XFILLER_0_0_105 VGND VGND VPWR VPWR sky130_fd_sc_hd__fill_1
X_5751_ clknet_leaf_6_clk _0035_ VGND VGND VPWR VPWR clk_div.counter\[6\] sky130_fd_sc_hd__dfxtp_1
X_4702_ clk_div.counter\[1\] clk_div.counter\[0\] clk_div.counter\[2\] VGND VGND VPWR
+ VPWR _2306_ sky130_fd_sc_hd__a21o_1
X_2963_ _0561_ _0550_ VGND VGND VPWR VPWR _0628_ sky130_fd_sc_hd__or2_1
XFILLER_0_56_141 VPWR VGND VPWR VGND sky130_ef_sc_hd__decap_12
XFILLER_0_56_130 VGND VGND VPWR VPWR sky130_fd_sc_hd__decap_8
X_5820_ _0523_ _0014_ VGND VGND VPWR VPWR alu.ALUResult\[26\] sky130_fd_sc_hd__dlxtn_1
X_2894_ _0540_ PC\[1\] VGND VGND VPWR VPWR _0559_ sky130_fd_sc_hd__nor2_1
X_4633_ _2071_ _2172_ _2130_ VGND VGND VPWR VPWR _2251_ sky130_fd_sc_hd__o21ai_1
X_3515_ _1107_ _1118_ _1179_ VGND VGND VPWR VPWR _1180_ sky130_fd_sc_hd__a21oi_1
X_4564_ _0806_ _2183_ _2186_ VGND VGND VPWR VPWR _2188_ sky130_fd_sc_hd__or3_1
X_5682_ reg_file.memory\[2\]\[12\] VGND VGND VPWR VPWR _2844_ sky130_fd_sc_hd__clkbuf_1
XFILLER_0_8_77 VGND VGND VPWR VPWR sky130_fd_sc_hd__decap_3
X_6096_ clknet_leaf_9_clk _0331_ VGND VGND VPWR VPWR reg_file.memory\[10\]\[30\] sky130_fd_sc_hd__dfxtp_1
X_5116_ _2546_ VGND VGND VPWR VPWR _0204_ sky130_fd_sc_hd__clkbuf_1
X_6165_ clknet_leaf_1_clk _0400_ VGND VGND VPWR VPWR reg_file.memory\[21\]\[3\] sky130_fd_sc_hd__dfxtp_1
X_4495_ _0903_ _2123_ VGND VGND VPWR VPWR _2125_ sky130_fd_sc_hd__or2_1
X_3446_ reg_file.memory\[5\]\[3\] _1110_ _0644_ VGND VGND VPWR VPWR _1111_ sky130_fd_sc_hd__mux2_1
X_6234_ clknet_leaf_2_clk _0469_ VGND VGND VPWR VPWR reg_file.memory\[2\]\[8\] sky130_fd_sc_hd__dfxtp_1
X_3377_ reg_file.memory\[8\]\[7\] reg_file.memory\[9\]\[7\] _0636_ VGND VGND VPWR
+ VPWR _1042_ sky130_fd_sc_hd__mux2_1
XFILLER_0_79_266 VGND VGND VPWR VPWR sky130_fd_sc_hd__fill_1
X_5047_ _2509_ VGND VGND VPWR VPWR _0172_ sky130_fd_sc_hd__clkbuf_1
XTAP_TAPCELL_ROW_63_570 VGND VPWR sky130_fd_sc_hd__tapvpwrvgnd_1
XFILLER_0_50_306 VGND VGND VPWR VPWR sky130_fd_sc_hd__fill_2
X_5949_ clknet_leaf_20_clk _0184_ VGND VGND VPWR VPWR reg_file.memory\[6\]\[11\] sky130_fd_sc_hd__dfxtp_1
XFILLER_0_62_177 VGND VGND VPWR VPWR sky130_fd_sc_hd__fill_2
XFILLER_0_85_236 VGND VGND VPWR VPWR sky130_fd_sc_hd__decap_4
XFILLER_0_85_214 VGND VGND VPWR VPWR sky130_fd_sc_hd__decap_8
XFILLER_0_53_177 VGND VGND VPWR VPWR sky130_fd_sc_hd__fill_2
XFILLER_0_53_166 VGND VGND VPWR VPWR sky130_fd_sc_hd__fill_2
XFILLER_0_26_347 VGND VGND VPWR VPWR sky130_fd_sc_hd__fill_1
X_4280_ _1921_ _1922_ _1733_ VGND VGND VPWR VPWR _1923_ sky130_fd_sc_hd__mux2_1
XTAP_TAPCELL_ROW_69_607 VGND VPWR sky130_fd_sc_hd__tapvpwrvgnd_1
XFILLER_0_39_55 VGND VGND VPWR VPWR sky130_fd_sc_hd__fill_1
X_3162_ _0574_ _0824_ _0826_ _0606_ VGND VGND VPWR VPWR _0827_ sky130_fd_sc_hd__o211a_1
X_3231_ reg_file.memory\[0\]\[16\] _0895_ _0655_ VGND VGND VPWR VPWR _0896_ sky130_fd_sc_hd__mux2_1
X_3300_ _0962_ _0964_ _0663_ VGND VGND VPWR VPWR _0965_ sky130_fd_sc_hd__mux2_1
XTAP_TAPCELL_ROW_77_651 VGND VPWR sky130_fd_sc_hd__tapvpwrvgnd_1
XFILLER_0_76_214 VGND VGND VPWR VPWR sky130_fd_sc_hd__decap_6
X_3093_ reg_file.memory\[4\]\[24\] reg_file.memory\[5\]\[24\] _0595_ VGND VGND VPWR
+ VPWR _0758_ sky130_fd_sc_hd__mux2_1
XFILLER_0_55_54 VGND VGND VPWR VPWR sky130_fd_sc_hd__fill_2
X_5734_ _2296_ net4 _2868_ _2293_ VGND VGND VPWR VPWR _0500_ sky130_fd_sc_hd__o22a_1
X_2877_ _0539_ _0541_ VGND VGND VPWR VPWR _0542_ sky130_fd_sc_hd__nor2_2
XTAP_TAPCELL_ROW_60_551 VGND VPWR sky130_fd_sc_hd__tapvpwrvgnd_1
X_5665_ _2835_ VGND VGND VPWR VPWR _0464_ sky130_fd_sc_hd__clkbuf_1
X_2946_ _0610_ VGND VGND VPWR VPWR _0611_ sky130_fd_sc_hd__clkbuf_4
X_5803_ _0536_ _0014_ VGND VGND VPWR VPWR alu.ALUResult\[9\] sky130_fd_sc_hd__dlxtn_1
X_3995_ _1624_ _0019_ VGND VGND VPWR VPWR _1645_ sky130_fd_sc_hd__nor2_1
XTAP_TAPCELL_ROW_17_294 VGND VPWR sky130_fd_sc_hd__tapvpwrvgnd_1
XFILLER_0_88_3 VGND VGND VPWR VPWR sky130_fd_sc_hd__fill_1
X_4547_ _2071_ _2074_ _2172_ _2064_ VGND VGND VPWR VPWR _2173_ sky130_fd_sc_hd__o22ai_1
X_4616_ _2060_ _2152_ _2235_ VGND VGND VPWR VPWR _2236_ sky130_fd_sc_hd__o21ai_1
X_5596_ _2413_ reg_file.memory\[25\]\[2\] _2797_ VGND VGND VPWR VPWR _2800_ sky130_fd_sc_hd__mux2_1
X_4478_ _0927_ _0934_ VGND VGND VPWR VPWR _2109_ sky130_fd_sc_hd__and2b_1
X_6217_ clknet_leaf_8_clk _0452_ VGND VGND VPWR VPWR reg_file.memory\[25\]\[23\] sky130_fd_sc_hd__dfxtp_1
X_3429_ reg_file.memory\[0\]\[4\] _1093_ _0653_ VGND VGND VPWR VPWR _1094_ sky130_fd_sc_hd__mux2_1
X_6079_ clknet_leaf_20_clk _0314_ VGND VGND VPWR VPWR reg_file.memory\[10\]\[13\]
+ sky130_fd_sc_hd__dfxtp_1
X_6148_ clknet_leaf_18_clk _0383_ VGND VGND VPWR VPWR reg_file.memory\[1\]\[18\] sky130_fd_sc_hd__dfxtp_1
XTAP_TAPCELL_ROW_83_687 VGND VPWR sky130_fd_sc_hd__tapvpwrvgnd_1
XFILLER_0_67_225 VGND VGND VPWR VPWR sky130_fd_sc_hd__fill_1
XTAP_TAPCELL_ROW_0_184 VGND VPWR sky130_fd_sc_hd__tapvpwrvgnd_1
XFILLER_0_90_272 VGND VGND VPWR VPWR sky130_fd_sc_hd__fill_2
XTAP_TAPCELL_ROW_8_240 VGND VPWR sky130_fd_sc_hd__tapvpwrvgnd_1
XTAP_TAPCELL_ROW_74_632 VGND VPWR sky130_fd_sc_hd__tapvpwrvgnd_1
XTAP_TAPCELL_ROW_14_275 VGND VPWR sky130_fd_sc_hd__tapvpwrvgnd_1
X_3780_ _1426_ _1435_ _1369_ VGND VGND VPWR VPWR _1436_ sky130_fd_sc_hd__a21o_1
X_5381_ reg_file.memory\[10\]\[29\] alu.ALUResult\[29\] _2676_ VGND VGND VPWR VPWR
+ _2686_ sky130_fd_sc_hd__mux2_1
XFILLER_0_81_272 VGND VGND VPWR VPWR sky130_fd_sc_hd__fill_2
X_5450_ _2469_ reg_file.memory\[15\]\[29\] _2713_ VGND VGND VPWR VPWR _2723_ sky130_fd_sc_hd__mux2_1
X_4332_ _1807_ VGND VGND VPWR VPWR _1973_ sky130_fd_sc_hd__inv_2
X_4401_ _1940_ _2037_ _2021_ _1868_ VGND VGND VPWR VPWR _2038_ sky130_fd_sc_hd__a2bb2o_1
XFILLER_0_41_169 VPWR VGND VPWR VGND sky130_ef_sc_hd__decap_12
XFILLER_0_1_211 VGND VGND VPWR VPWR sky130_fd_sc_hd__fill_1
X_4194_ _1837_ _1838_ VGND VGND VPWR VPWR _1839_ sky130_fd_sc_hd__and2_1
X_4263_ _1899_ _1903_ _1902_ _1906_ VGND VGND VPWR VPWR _0527_ sky130_fd_sc_hd__o2bb2a_1
X_3145_ _0600_ _0809_ VGND VGND VPWR VPWR _0810_ sky130_fd_sc_hd__or2_1
X_6002_ clknet_leaf_27_clk _0237_ VGND VGND VPWR VPWR reg_file.memory\[8\]\[0\] sky130_fd_sc_hd__dfxtp_1
X_3214_ reg_file.memory\[5\]\[17\] _0878_ _0647_ VGND VGND VPWR VPWR _0879_ sky130_fd_sc_hd__mux2_1
XTAP_TAPCELL_ROW_80_668 VGND VPWR sky130_fd_sc_hd__tapvpwrvgnd_1
X_3076_ reg_file.memory\[0\]\[25\] reg_file.memory\[1\]\[25\] _0594_ VGND VGND VPWR
+ VPWR _0741_ sky130_fd_sc_hd__mux2_1
XFILLER_0_49_225 VPWR VGND VPWR VGND sky130_ef_sc_hd__decap_12
X_5717_ _2861_ VGND VGND VPWR VPWR _0490_ sky130_fd_sc_hd__clkbuf_1
X_5648_ _2465_ reg_file.memory\[25\]\[27\] _2819_ VGND VGND VPWR VPWR _2827_ sky130_fd_sc_hd__mux2_1
X_2929_ _0593_ VGND VGND VPWR VPWR _0594_ sky130_fd_sc_hd__clkbuf_4
X_3978_ _1614_ _1618_ _1344_ VGND VGND VPWR VPWR _1632_ sky130_fd_sc_hd__a21oi_1
XFILLER_0_17_111 VGND VGND VPWR VPWR sky130_fd_sc_hd__fill_1
XFILLER_0_17_166 VGND VGND VPWR VPWR sky130_fd_sc_hd__fill_2
XFILLER_0_17_188 VGND VGND VPWR VPWR sky130_fd_sc_hd__fill_1
X_5579_ _2465_ reg_file.memory\[21\]\[27\] _2782_ VGND VGND VPWR VPWR _2790_ sky130_fd_sc_hd__mux2_1
XTAP_TAPCELL_ROW_5_221 VGND VPWR sky130_fd_sc_hd__tapvpwrvgnd_1
XTAP_TAPCELL_ROW_28_356 VGND VPWR sky130_fd_sc_hd__tapvpwrvgnd_1
XFILLER_0_70_209 VGND VGND VPWR VPWR sky130_fd_sc_hd__decap_8
XTAP_TAPCELL_ROW_11_256 VGND VPWR sky130_fd_sc_hd__tapvpwrvgnd_1
XFILLER_0_23_169 VGND VGND VPWR VPWR sky130_fd_sc_hd__fill_2
XFILLER_0_86_320 VGND VGND VPWR VPWR sky130_fd_sc_hd__fill_1
X_4881_ _1328_ _2406_ VGND VGND VPWR VPWR _2407_ sky130_fd_sc_hd__or2_1
X_4950_ _2454_ VGND VGND VPWR VPWR _0130_ sky130_fd_sc_hd__clkbuf_1
X_3901_ _1545_ _1547_ VGND VGND VPWR VPWR _1557_ sky130_fd_sc_hd__or2b_1
X_5502_ reg_file.memory\[1\]\[23\] VGND VGND VPWR VPWR _2749_ sky130_fd_sc_hd__clkbuf_1
X_3832_ _1485_ _1477_ _1474_ VGND VGND VPWR VPWR _1488_ sky130_fd_sc_hd__mux2_1
X_3694_ _1350_ VGND VGND VPWR VPWR _0016_ sky130_fd_sc_hd__buf_6
X_3763_ _1416_ _1417_ _1418_ VGND VGND VPWR VPWR _1419_ sky130_fd_sc_hd__or3_1
X_4315_ _1182_ _1956_ VGND VGND VPWR VPWR _1957_ sky130_fd_sc_hd__xnor2_1
X_5433_ _2714_ VGND VGND VPWR VPWR _0353_ sky130_fd_sc_hd__clkbuf_1
X_5295_ reg_file.memory\[0\]\[20\] VGND VGND VPWR VPWR _2641_ sky130_fd_sc_hd__clkbuf_1
X_5364_ _2677_ VGND VGND VPWR VPWR _0321_ sky130_fd_sc_hd__clkbuf_1
X_4246_ _1678_ _1730_ _1154_ VGND VGND VPWR VPWR _1890_ sky130_fd_sc_hd__mux2_1
X_4177_ _1819_ _1821_ VGND VGND VPWR VPWR _1822_ sky130_fd_sc_hd__nor2_1
X_3128_ reg_file.memory\[0\]\[22\] reg_file.memory\[1\]\[22\] _0594_ VGND VGND VPWR
+ VPWR _0793_ sky130_fd_sc_hd__mux2_1
XTAP_TAPCELL_ROW_2_202 VGND VPWR sky130_fd_sc_hd__tapvpwrvgnd_1
X_3059_ reg_file.memory\[0\]\[26\] reg_file.memory\[1\]\[26\] _0593_ VGND VGND VPWR
+ VPWR _0724_ sky130_fd_sc_hd__mux2_1
XFILLER_0_60_253 VGND VGND VPWR VPWR sky130_fd_sc_hd__fill_1
XFILLER_0_87_106 VGND VGND VPWR VPWR sky130_fd_sc_hd__decap_6
X_4031_ _1675_ _1676_ VGND VGND VPWR VPWR _1677_ sky130_fd_sc_hd__nand2_1
X_4100_ _1689_ _1745_ VGND VGND VPWR VPWR _1746_ sky130_fd_sc_hd__nand2_1
X_5080_ _2438_ reg_file.memory\[6\]\[14\] _2523_ VGND VGND VPWR VPWR _2528_ sky130_fd_sc_hd__mux2_1
X_4864_ reg_file.memory\[9\]\[27\] VGND VGND VPWR VPWR _2396_ sky130_fd_sc_hd__clkbuf_1
XTAP_TAPCELL_ROW_90_730 VGND VPWR sky130_fd_sc_hd__tapvpwrvgnd_1
XFILLER_0_78_139 VGND VGND VPWR VPWR sky130_fd_sc_hd__fill_1
XTAP_TAPCELL_ROW_47_473 VGND VPWR sky130_fd_sc_hd__tapvpwrvgnd_1
X_5982_ clknet_leaf_23_clk _0217_ VGND VGND VPWR VPWR reg_file.memory\[7\]\[12\] sky130_fd_sc_hd__dfxtp_1
XFILLER_0_6_100 VPWR VGND VPWR VGND sky130_ef_sc_hd__decap_12
X_4933_ _2442_ reg_file.memory\[4\]\[16\] _2430_ VGND VGND VPWR VPWR _2443_ sky130_fd_sc_hd__mux2_1
XFILLER_0_19_228 VGND VGND VPWR VPWR sky130_fd_sc_hd__fill_1
X_3677_ _1336_ _1330_ ctrl_unit.PCWrite VGND VGND VPWR VPWR _1337_ sky130_fd_sc_hd__mux2_1
XFILLER_0_70_3 VPWR VGND VPWR VGND sky130_ef_sc_hd__decap_12
XFILLER_0_42_253 VGND VGND VPWR VPWR sky130_fd_sc_hd__fill_1
X_5416_ _2705_ VGND VGND VPWR VPWR _0345_ sky130_fd_sc_hd__clkbuf_1
XTAP_TAPCELL_ROW_30_373 VGND VPWR sky130_fd_sc_hd__tapvpwrvgnd_1
X_3746_ _1394_ _1401_ _1399_ VGND VGND VPWR VPWR _1402_ sky130_fd_sc_hd__and3_1
X_3815_ _1366_ _1464_ _1470_ VGND VGND VPWR VPWR _1471_ sky130_fd_sc_hd__a21bo_1
XFILLER_0_6_144 VGND VGND VPWR VPWR sky130_fd_sc_hd__fill_1
X_4795_ _2361_ VGND VGND VPWR VPWR _0068_ sky130_fd_sc_hd__clkbuf_1
X_4229_ _1157_ _1864_ VGND VGND VPWR VPWR _1874_ sky130_fd_sc_hd__nor2_1
XFILLER_0_2_361 VGND VGND VPWR VPWR sky130_fd_sc_hd__decap_3
XFILLER_0_10_194 VGND VGND VPWR VPWR sky130_fd_sc_hd__fill_2
X_5347_ _2668_ VGND VGND VPWR VPWR _0313_ sky130_fd_sc_hd__clkbuf_1
X_5278_ _2632_ VGND VGND VPWR VPWR _0280_ sky130_fd_sc_hd__clkbuf_1
XFILLER_0_84_109 VPWR VGND VPWR VGND sky130_ef_sc_hd__decap_12
XFILLER_0_0_309 VPWR VGND VPWR VGND sky130_ef_sc_hd__decap_12
XFILLER_0_68_194 VGND VGND VPWR VPWR sky130_fd_sc_hd__fill_2
XTAP_TAPCELL_ROW_44_454 VGND VPWR sky130_fd_sc_hd__tapvpwrvgnd_1
XFILLER_0_33_57 VGND VGND VPWR VPWR sky130_fd_sc_hd__fill_1
XFILLER_0_83_197 VGND VGND VPWR VPWR sky130_fd_sc_hd__fill_1
XFILLER_0_71_304 VGND VGND VPWR VPWR sky130_fd_sc_hd__fill_2
X_4580_ _2060_ _2116_ _2202_ _2064_ VGND VGND VPWR VPWR _2203_ sky130_fd_sc_hd__o22ai_1
X_3600_ _1225_ _1264_ VGND VGND VPWR VPWR _1265_ sky130_fd_sc_hd__xnor2_1
X_3531_ _1006_ _1013_ VGND VGND VPWR VPWR _1196_ sky130_fd_sc_hd__or2_1
XFILLER_0_24_253 VGND VGND VPWR VPWR sky130_fd_sc_hd__fill_1
XFILLER_0_3_169 VGND VGND VPWR VPWR sky130_fd_sc_hd__fill_1
XFILLER_0_3_103 VGND VGND VPWR VPWR sky130_fd_sc_hd__fill_1
X_6250_ clknet_leaf_11_clk _0485_ VGND VGND VPWR VPWR reg_file.memory\[2\]\[24\] sky130_fd_sc_hd__dfxtp_1
X_3462_ _1125_ _1126_ _1055_ VGND VGND VPWR VPWR _1127_ sky130_fd_sc_hd__a21o_1
X_5132_ _2555_ VGND VGND VPWR VPWR _0211_ sky130_fd_sc_hd__clkbuf_1
X_6181_ clknet_leaf_22_clk _0416_ VGND VGND VPWR VPWR reg_file.memory\[21\]\[19\]
+ sky130_fd_sc_hd__dfxtp_1
Xclkbuf_1_0__f_clk clknet_0_clk VGND VGND VPWR VPWR clknet_1_0__leaf_clk sky130_fd_sc_hd__clkbuf_16
X_5201_ reg_file.memory\[8\]\[6\] alu.ALUResult\[6\] _2586_ VGND VGND VPWR VPWR _2593_
+ sky130_fd_sc_hd__mux2_1
X_3393_ reg_file.memory\[5\]\[6\] _1057_ _0645_ VGND VGND VPWR VPWR _1058_ sky130_fd_sc_hd__mux2_1
XFILLER_0_74_64 VGND VGND VPWR VPWR sky130_fd_sc_hd__fill_2
XFILLER_0_74_42 VGND VGND VPWR VPWR sky130_fd_sc_hd__fill_1
XFILLER_0_66_109 VGND VGND VPWR VPWR sky130_fd_sc_hd__decap_6
X_4014_ _1022_ _1038_ _1056_ _1252_ VGND VGND VPWR VPWR _1660_ sky130_fd_sc_hd__and4_1
X_5063_ _2421_ reg_file.memory\[6\]\[6\] _2512_ VGND VGND VPWR VPWR _2519_ sky130_fd_sc_hd__mux2_1
XFILLER_0_90_85 VPWR VGND VPWR VGND sky130_ef_sc_hd__decap_12
XFILLER_0_90_41 VGND VGND VPWR VPWR sky130_fd_sc_hd__fill_2
XFILLER_0_74_197 VGND VGND VPWR VPWR sky130_fd_sc_hd__decap_6
X_5965_ clknet_leaf_12_clk _0200_ VGND VGND VPWR VPWR reg_file.memory\[6\]\[27\] sky130_fd_sc_hd__dfxtp_1
X_5896_ clknet_leaf_12_clk _0131_ VGND VGND VPWR VPWR reg_file.memory\[4\]\[22\] sky130_fd_sc_hd__dfxtp_1
X_4916_ _2431_ VGND VGND VPWR VPWR _0119_ sky130_fd_sc_hd__clkbuf_1
X_4847_ _2387_ VGND VGND VPWR VPWR _0094_ sky130_fd_sc_hd__clkbuf_1
X_3729_ _1375_ _1384_ _1346_ VGND VGND VPWR VPWR _1385_ sky130_fd_sc_hd__o21a_1
X_4778_ _2340_ seven_seg_conv.temp\[13\] _2352_ VGND VGND VPWR VPWR _0060_ sky130_fd_sc_hd__a21o_1
XFILLER_0_65_175 VGND VGND VPWR VPWR sky130_fd_sc_hd__fill_1
XFILLER_0_65_153 VGND VGND VPWR VPWR sky130_fd_sc_hd__decap_6
XTAP_TAPCELL_ROW_41_435 VGND VPWR sky130_fd_sc_hd__tapvpwrvgnd_1
XFILLER_0_21_223 VGND VGND VPWR VPWR sky130_fd_sc_hd__fill_1
X_4701_ _2304_ VGND VGND VPWR VPWR _2305_ sky130_fd_sc_hd__inv_2
X_5750_ clknet_leaf_6_clk _0034_ VGND VGND VPWR VPWR clk_div.counter\[5\] sky130_fd_sc_hd__dfxtp_1
X_2893_ PC\[3\] VGND VGND VPWR VPWR _0558_ sky130_fd_sc_hd__inv_2
X_2962_ reg_file.memory\[21\]\[30\] _0546_ _0619_ _0626_ VGND VGND VPWR VPWR _0627_
+ sky130_fd_sc_hd__o211ai_2
X_4632_ _1738_ _2212_ _2248_ _2249_ _1742_ VGND VGND VPWR VPWR _2250_ sky130_fd_sc_hd__o221a_1
XFILLER_0_60_55 VGND VGND VPWR VPWR sky130_fd_sc_hd__decap_3
XFILLER_0_56_197 VPWR VGND VPWR VGND sky130_ef_sc_hd__decap_12
XFILLER_0_56_153 VPWR VGND VPWR VGND sky130_ef_sc_hd__decap_12
XFILLER_0_44_337 VGND VGND VPWR VPWR sky130_fd_sc_hd__fill_1
X_5681_ _2843_ VGND VGND VPWR VPWR _0472_ sky130_fd_sc_hd__clkbuf_1
XFILLER_0_29_301 VGND VGND VPWR VPWR sky130_fd_sc_hd__decap_3
X_3514_ _1128_ _1137_ _1178_ VGND VGND VPWR VPWR _1179_ sky130_fd_sc_hd__o21ba_1
X_4563_ _2183_ _2186_ _0806_ VGND VGND VPWR VPWR _2187_ sky130_fd_sc_hd__o21a_1
X_3445_ reg_file.memory\[6\]\[3\] reg_file.memory\[7\]\[3\] _0635_ VGND VGND VPWR
+ VPWR _1110_ sky130_fd_sc_hd__mux2_1
X_4494_ _0903_ _2123_ VGND VGND VPWR VPWR _2124_ sky130_fd_sc_hd__nand2_1
X_6233_ clknet_leaf_0_clk _0468_ VGND VGND VPWR VPWR reg_file.memory\[2\]\[7\] sky130_fd_sc_hd__dfxtp_1
X_6095_ clknet_leaf_9_clk _0330_ VGND VGND VPWR VPWR reg_file.memory\[10\]\[29\] sky130_fd_sc_hd__dfxtp_1
X_5046_ _2367_ reg_file.memory\[5\]\[31\] _2474_ VGND VGND VPWR VPWR _2509_ sky130_fd_sc_hd__mux2_1
X_5115_ _2367_ reg_file.memory\[6\]\[31\] _2511_ VGND VGND VPWR VPWR _2546_ sky130_fd_sc_hd__mux2_1
X_6164_ clknet_leaf_3_clk _0399_ VGND VGND VPWR VPWR reg_file.memory\[21\]\[2\] sky130_fd_sc_hd__dfxtp_1
X_3376_ reg_file.memory\[0\]\[7\] _1040_ _0654_ VGND VGND VPWR VPWR _1041_ sky130_fd_sc_hd__mux2_1
XTAP_TAPCELL_ROW_63_571 VGND VPWR sky130_fd_sc_hd__tapvpwrvgnd_1
X_5948_ clknet_leaf_24_clk _0183_ VGND VGND VPWR VPWR reg_file.memory\[6\]\[10\] sky130_fd_sc_hd__dfxtp_1
XFILLER_0_62_101 VGND VGND VPWR VPWR sky130_fd_sc_hd__fill_1
X_5879_ clknet_leaf_0_clk _0114_ VGND VGND VPWR VPWR reg_file.memory\[4\]\[5\] sky130_fd_sc_hd__dfxtp_1
XFILLER_0_41_318 VGND VGND VPWR VPWR sky130_fd_sc_hd__fill_1
XFILLER_0_55_44 VGND VGND VPWR VPWR sky130_fd_sc_hd__fill_1
XFILLER_0_39_78 VGND VGND VPWR VPWR sky130_fd_sc_hd__fill_1
X_3161_ _0600_ _0825_ VGND VGND VPWR VPWR _0826_ sky130_fd_sc_hd__or2_1
X_3230_ reg_file.memory\[5\]\[16\] _0894_ _0647_ VGND VGND VPWR VPWR _0895_ sky130_fd_sc_hd__mux2_1
XTAP_TAPCELL_ROW_77_652 VGND VPWR sky130_fd_sc_hd__tapvpwrvgnd_1
X_3092_ reg_file.memory\[7\]\[24\] _0674_ _0601_ reg_file.memory\[2\]\[24\] _0581_
+ VGND VGND VPWR VPWR _0757_ sky130_fd_sc_hd__o221a_1
X_5802_ _0535_ _0014_ VGND VGND VPWR VPWR alu.ALUResult\[8\] sky130_fd_sc_hd__dlxtn_1
X_5733_ _2296_ net5 _2868_ _2291_ VGND VGND VPWR VPWR _0499_ sky130_fd_sc_hd__o22a_1
XFILLER_0_84_281 VGND VGND VPWR VPWR sky130_fd_sc_hd__fill_2
X_2876_ _0540_ PC\[1\] VGND VGND VPWR VPWR _0541_ sky130_fd_sc_hd__nand2_2
X_5595_ _2799_ VGND VGND VPWR VPWR _0430_ sky130_fd_sc_hd__clkbuf_1
X_4615_ _1816_ _2192_ _2234_ _1940_ VGND VGND VPWR VPWR _2235_ sky130_fd_sc_hd__a211o_1
XTAP_TAPCELL_ROW_60_552 VGND VPWR sky130_fd_sc_hd__tapvpwrvgnd_1
X_5664_ reg_file.memory\[2\]\[3\] VGND VGND VPWR VPWR _2835_ sky130_fd_sc_hd__clkbuf_1
X_2945_ _0609_ VGND VGND VPWR VPWR _0610_ sky130_fd_sc_hd__buf_2
X_3994_ _0016_ _0019_ _1624_ VGND VGND VPWR VPWR _1644_ sky130_fd_sc_hd__o21a_1
XTAP_TAPCELL_ROW_17_295 VGND VPWR sky130_fd_sc_hd__tapvpwrvgnd_1
X_4546_ _2127_ _2171_ _1789_ VGND VGND VPWR VPWR _2172_ sky130_fd_sc_hd__mux2_1
X_6216_ clknet_leaf_13_clk _0451_ VGND VGND VPWR VPWR reg_file.memory\[25\]\[22\]
+ sky130_fd_sc_hd__dfxtp_1
X_4477_ _1275_ _1994_ _2099_ _2108_ VGND VGND VPWR VPWR _0510_ sky130_fd_sc_hd__a211o_1
XFILLER_0_40_362 VGND VGND VPWR VPWR sky130_fd_sc_hd__fill_2
X_3428_ reg_file.memory\[5\]\[4\] _1092_ _0644_ VGND VGND VPWR VPWR _1093_ sky130_fd_sc_hd__mux2_1
X_5029_ _2500_ VGND VGND VPWR VPWR _0163_ sky130_fd_sc_hd__clkbuf_1
X_3359_ reg_file.memory\[5\]\[8\] _1023_ _0645_ VGND VGND VPWR VPWR _1024_ sky130_fd_sc_hd__mux2_1
X_6147_ clknet_leaf_18_clk _0382_ VGND VGND VPWR VPWR reg_file.memory\[1\]\[17\] sky130_fd_sc_hd__dfxtp_1
X_6078_ clknet_leaf_25_clk _0313_ VGND VGND VPWR VPWR reg_file.memory\[10\]\[12\]
+ sky130_fd_sc_hd__dfxtp_1
XTAP_TAPCELL_ROW_83_688 VGND VPWR sky130_fd_sc_hd__tapvpwrvgnd_1
XFILLER_0_82_229 VGND VGND VPWR VPWR sky130_fd_sc_hd__decap_4
XTAP_TAPCELL_ROW_0_185 VGND VPWR sky130_fd_sc_hd__tapvpwrvgnd_1
XTAP_TAPCELL_ROW_8_241 VGND VPWR sky130_fd_sc_hd__tapvpwrvgnd_1
XTAP_TAPCELL_ROW_74_633 VGND VPWR sky130_fd_sc_hd__tapvpwrvgnd_1
XFILLER_0_58_259 VGND VGND VPWR VPWR sky130_fd_sc_hd__fill_1
XFILLER_0_41_46 VGND VGND VPWR VPWR sky130_fd_sc_hd__fill_1
XFILLER_0_26_134 VGND VGND VPWR VPWR sky130_fd_sc_hd__fill_1
XTAP_TAPCELL_ROW_14_276 VGND VPWR sky130_fd_sc_hd__tapvpwrvgnd_1
X_5380_ _2685_ VGND VGND VPWR VPWR _0329_ sky130_fd_sc_hd__clkbuf_1
X_4331_ _1845_ _1964_ _1965_ _1967_ _1971_ VGND VGND VPWR VPWR _1972_ sky130_fd_sc_hd__a311o_1
X_4400_ _1969_ _2036_ _1704_ VGND VGND VPWR VPWR _2037_ sky130_fd_sc_hd__mux2_1
X_4262_ _1904_ _1905_ VGND VGND VPWR VPWR _1906_ sky130_fd_sc_hd__and2_1
XFILLER_0_5_35 VGND VGND VPWR VPWR sky130_fd_sc_hd__fill_2
XFILLER_0_1_223 VGND VGND VPWR VPWR sky130_fd_sc_hd__fill_1
X_3075_ reg_file.memory\[4\]\[25\] reg_file.memory\[5\]\[25\] _0595_ VGND VGND VPWR
+ VPWR _0740_ sky130_fd_sc_hd__mux2_1
X_4193_ _1710_ _1771_ VGND VGND VPWR VPWR _1838_ sky130_fd_sc_hd__nand2_1
X_6001_ clknet_leaf_13_clk _0236_ VGND VGND VPWR VPWR reg_file.memory\[7\]\[31\] sky130_fd_sc_hd__dfxtp_1
X_3144_ reg_file.memory\[0\]\[21\] reg_file.memory\[1\]\[21\] _0593_ VGND VGND VPWR
+ VPWR _0809_ sky130_fd_sc_hd__mux2_1
XFILLER_0_5_68 VGND VGND VPWR VPWR sky130_fd_sc_hd__fill_1
X_3213_ reg_file.memory\[6\]\[17\] reg_file.memory\[7\]\[17\] _0638_ VGND VGND VPWR
+ VPWR _0878_ sky130_fd_sc_hd__mux2_1
XTAP_TAPCELL_ROW_80_669 VGND VPWR sky130_fd_sc_hd__tapvpwrvgnd_1
XFILLER_0_49_259 VGND VGND VPWR VPWR sky130_fd_sc_hd__fill_1
XFILLER_0_49_237 VGND VGND VPWR VPWR sky130_fd_sc_hd__fill_2
X_3977_ _1614_ _1620_ _1618_ VGND VGND VPWR VPWR _1631_ sky130_fd_sc_hd__a21o_1
X_5716_ reg_file.memory\[2\]\[29\] VGND VGND VPWR VPWR _2861_ sky130_fd_sc_hd__clkbuf_1
X_5647_ _2826_ VGND VGND VPWR VPWR _0455_ sky130_fd_sc_hd__clkbuf_1
X_5578_ _2789_ VGND VGND VPWR VPWR _0423_ sky130_fd_sc_hd__clkbuf_1
X_2928_ _0592_ VGND VGND VPWR VPWR _0593_ sky130_fd_sc_hd__clkbuf_4
X_4529_ _1809_ _1811_ VGND VGND VPWR VPWR _2156_ sky130_fd_sc_hd__nand2_1
XTAP_TAPCELL_ROW_5_222 VGND VPWR sky130_fd_sc_hd__tapvpwrvgnd_1
XTAP_TAPCELL_ROW_71_614 VGND VPWR sky130_fd_sc_hd__tapvpwrvgnd_1
XTAP_TAPCELL_ROW_28_357 VGND VPWR sky130_fd_sc_hd__tapvpwrvgnd_1
XFILLER_0_31_181 VGND VGND VPWR VPWR sky130_fd_sc_hd__fill_1
XTAP_TAPCELL_ROW_11_257 VGND VPWR sky130_fd_sc_hd__tapvpwrvgnd_1
XTAP_TAPCELL_ROW_19_302 VGND VPWR sky130_fd_sc_hd__tapvpwrvgnd_1
X_4880_ ctrl_unit.RegWrite _1330_ VGND VGND VPWR VPWR _2406_ sky130_fd_sc_hd__nand2_1
XFILLER_0_52_45 VGND VGND VPWR VPWR sky130_fd_sc_hd__fill_2
X_3831_ _1482_ _1483_ _1484_ _1486_ VGND VGND VPWR VPWR _1487_ sky130_fd_sc_hd__a2bb2o_1
X_3900_ _1551_ _1552_ _1554_ _1555_ VGND VGND VPWR VPWR _1556_ sky130_fd_sc_hd__o211ai_2
X_5501_ _2748_ VGND VGND VPWR VPWR _0387_ sky130_fd_sc_hd__clkbuf_1
XFILLER_0_39_281 VGND VGND VPWR VPWR sky130_fd_sc_hd__fill_1
X_5432_ _2450_ reg_file.memory\[15\]\[20\] _2713_ VGND VGND VPWR VPWR _2714_ sky130_fd_sc_hd__mux2_1
X_3762_ alu.ALUResult\[23\] seven_seg_conv.temp\[23\] _1351_ VGND VGND VPWR VPWR _1418_
+ sky130_fd_sc_hd__mux2_1
X_3693_ seven_seg_conv.current_digit\[0\] _1348_ _1349_ VGND VGND VPWR VPWR _1350_
+ sky130_fd_sc_hd__mux2_1
X_4245_ _1657_ VGND VGND VPWR VPWR _1889_ sky130_fd_sc_hd__buf_2
XFILLER_0_77_64 VGND VGND VPWR VPWR sky130_fd_sc_hd__fill_2
X_4314_ _1291_ _1908_ _1955_ VGND VGND VPWR VPWR _1956_ sky130_fd_sc_hd__a21oi_1
X_5363_ reg_file.memory\[10\]\[20\] alu.ALUResult\[20\] _2676_ VGND VGND VPWR VPWR
+ _2677_ sky130_fd_sc_hd__mux2_1
X_5294_ _2640_ VGND VGND VPWR VPWR _0288_ sky130_fd_sc_hd__clkbuf_1
X_4176_ _1689_ _1716_ _1820_ VGND VGND VPWR VPWR _1821_ sky130_fd_sc_hd__a21bo_1
X_3127_ reg_file.memory\[4\]\[22\] reg_file.memory\[5\]\[22\] _0595_ VGND VGND VPWR
+ VPWR _0792_ sky130_fd_sc_hd__mux2_1
X_3058_ reg_file.memory\[4\]\[26\] reg_file.memory\[5\]\[26\] _0594_ VGND VGND VPWR
+ VPWR _0723_ sky130_fd_sc_hd__mux2_1
XTAP_TAPCELL_ROW_2_203 VGND VPWR sky130_fd_sc_hd__tapvpwrvgnd_1
XTAP_TAPCELL_ROW_25_338 VGND VPWR sky130_fd_sc_hd__tapvpwrvgnd_1
XFILLER_0_83_335 VGND VGND VPWR VPWR sky130_fd_sc_hd__fill_1
XFILLER_0_36_251 VGND VGND VPWR VPWR sky130_fd_sc_hd__fill_1
XFILLER_0_11_129 VGND VGND VPWR VPWR sky130_fd_sc_hd__fill_2
X_4030_ _0805_ _1670_ VGND VGND VPWR VPWR _1676_ sky130_fd_sc_hd__nand2_1
XPHY_EDGE_ROW_10_Right_10 VGND VGND VPWR VPWR sky130_fd_sc_hd__decap_3
X_5981_ clknet_leaf_24_clk _0216_ VGND VGND VPWR VPWR reg_file.memory\[7\]\[11\] sky130_fd_sc_hd__dfxtp_1
XTAP_TAPCELL_ROW_90_731 VGND VPWR sky130_fd_sc_hd__tapvpwrvgnd_1
X_4863_ _2395_ VGND VGND VPWR VPWR _0102_ sky130_fd_sc_hd__clkbuf_1
XTAP_TAPCELL_ROW_47_474 VGND VPWR sky130_fd_sc_hd__tapvpwrvgnd_1
X_3814_ _1367_ _1444_ _1452_ _1456_ VGND VGND VPWR VPWR _1470_ sky130_fd_sc_hd__a31o_1
XFILLER_0_6_112 VPWR VGND VPWR VGND sky130_ef_sc_hd__decap_12
X_4794_ seven_seg_conv.temp\[21\] _2360_ _1635_ VGND VGND VPWR VPWR _2361_ sky130_fd_sc_hd__mux2_1
X_4932_ alu.ALUResult\[16\] VGND VGND VPWR VPWR _2442_ sky130_fd_sc_hd__buf_1
XFILLER_0_88_85 VGND VGND VPWR VPWR sky130_fd_sc_hd__fill_2
X_3676_ _0547_ _0561_ _0542_ VGND VGND VPWR VPWR _1336_ sky130_fd_sc_hd__o21ba_1
X_5415_ _2434_ reg_file.memory\[15\]\[12\] _2702_ VGND VGND VPWR VPWR _2705_ sky130_fd_sc_hd__mux2_1
X_3745_ _1395_ _1396_ VGND VGND VPWR VPWR _1401_ sky130_fd_sc_hd__and2_1
XFILLER_0_6_167 VPWR VGND VPWR VGND sky130_ef_sc_hd__decap_12
X_4228_ _1176_ _1794_ _1872_ VGND VGND VPWR VPWR _1873_ sky130_fd_sc_hd__and3_1
X_5346_ reg_file.memory\[10\]\[12\] alu.ALUResult\[12\] _2665_ VGND VGND VPWR VPWR
+ _2668_ sky130_fd_sc_hd__mux2_1
X_5277_ reg_file.memory\[0\]\[11\] VGND VGND VPWR VPWR _2632_ sky130_fd_sc_hd__clkbuf_1
X_4159_ _1689_ _1676_ VGND VGND VPWR VPWR _1804_ sky130_fd_sc_hd__nand2_1
XFILLER_0_18_251 VGND VGND VPWR VPWR sky130_fd_sc_hd__fill_1
XFILLER_0_68_184 VGND VGND VPWR VPWR sky130_fd_sc_hd__fill_1
XTAP_TAPCELL_ROW_44_455 VGND VPWR sky130_fd_sc_hd__tapvpwrvgnd_1
Xclkbuf_leaf_26_clk clknet_1_0__leaf_clk VGND VGND VPWR VPWR clknet_leaf_26_clk sky130_fd_sc_hd__clkbuf_8
X_3461_ reg_file.memory\[21\]\[2\] _0543_ VGND VGND VPWR VPWR _1126_ sky130_fd_sc_hd__or2_1
X_3530_ _1046_ _1192_ _1194_ VGND VGND VPWR VPWR _1195_ sky130_fd_sc_hd__a21o_1
X_4013_ _1165_ VGND VGND VPWR VPWR _1659_ sky130_fd_sc_hd__buf_2
XFILLER_0_74_10 VGND VGND VPWR VPWR sky130_fd_sc_hd__decap_8
X_6180_ clknet_leaf_22_clk _0415_ VGND VGND VPWR VPWR reg_file.memory\[21\]\[18\]
+ sky130_fd_sc_hd__dfxtp_1
X_5131_ _2421_ reg_file.memory\[7\]\[6\] _2548_ VGND VGND VPWR VPWR _2555_ sky130_fd_sc_hd__mux2_1
X_3392_ reg_file.memory\[6\]\[6\] reg_file.memory\[7\]\[6\] _0636_ VGND VGND VPWR
+ VPWR _1057_ sky130_fd_sc_hd__mux2_1
X_5062_ _2518_ VGND VGND VPWR VPWR _0178_ sky130_fd_sc_hd__clkbuf_1
X_5200_ _2592_ VGND VGND VPWR VPWR _0242_ sky130_fd_sc_hd__clkbuf_1
XFILLER_0_59_151 VGND VGND VPWR VPWR sky130_fd_sc_hd__fill_1
X_5964_ clknet_leaf_16_clk _0199_ VGND VGND VPWR VPWR reg_file.memory\[6\]\[26\] sky130_fd_sc_hd__dfxtp_1
XTAP_TAPCELL_ROW_35_400 VGND VPWR sky130_fd_sc_hd__tapvpwrvgnd_1
Xclkbuf_leaf_17_clk clknet_1_0__leaf_clk VGND VGND VPWR VPWR clknet_leaf_17_clk sky130_fd_sc_hd__clkbuf_8
XFILLER_0_90_97 VPWR VGND VPWR VGND sky130_ef_sc_hd__decap_12
X_5895_ clknet_leaf_16_clk _0130_ VGND VGND VPWR VPWR reg_file.memory\[4\]\[21\] sky130_fd_sc_hd__dfxtp_1
X_4915_ _2429_ reg_file.memory\[4\]\[10\] _2430_ VGND VGND VPWR VPWR _2431_ sky130_fd_sc_hd__mux2_1
X_4777_ _1504_ _1506_ _2341_ VGND VGND VPWR VPWR _2352_ sky130_fd_sc_hd__a21oi_1
X_4846_ reg_file.memory\[9\]\[18\] VGND VGND VPWR VPWR _2387_ sky130_fd_sc_hd__clkbuf_1
X_3659_ _1317_ _1319_ _1321_ _1323_ VGND VGND VPWR VPWR _1324_ sky130_fd_sc_hd__and4b_1
X_3728_ alu.ALUResult\[29\] alu.ALUResult\[31\] _1376_ VGND VGND VPWR VPWR _1384_
+ sky130_fd_sc_hd__and3b_1
X_5329_ reg_file.memory\[10\]\[4\] alu.ALUResult\[4\] _2654_ VGND VGND VPWR VPWR _2659_
+ sky130_fd_sc_hd__mux2_1
XTAP_TAPCELL_ROW_58_536 VGND VPWR sky130_fd_sc_hd__tapvpwrvgnd_1
XFILLER_0_65_143 VGND VGND VPWR VPWR sky130_fd_sc_hd__fill_1
XTAP_TAPCELL_ROW_41_436 VGND VPWR sky130_fd_sc_hd__tapvpwrvgnd_1
XFILLER_0_21_246 VGND VGND VPWR VPWR sky130_fd_sc_hd__decap_3
X_4700_ clk_div.counter\[1\] clk_div.counter\[0\] clk_div.counter\[2\] VGND VGND VPWR
+ VPWR _2304_ sky130_fd_sc_hd__and3_1
X_2892_ _0540_ _0556_ PC\[4\] VGND VGND VPWR VPWR _0557_ sky130_fd_sc_hd__a21oi_2
X_4631_ _1963_ _1724_ _1727_ _1768_ VGND VGND VPWR VPWR _2249_ sky130_fd_sc_hd__a31o_1
XFILLER_0_60_89 VGND VGND VPWR VPWR sky130_fd_sc_hd__fill_1
XFILLER_0_56_165 VGND VGND VPWR VPWR sky130_fd_sc_hd__decap_4
X_2961_ _0625_ VGND VGND VPWR VPWR _0626_ sky130_fd_sc_hd__clkbuf_8
X_5680_ reg_file.memory\[2\]\[11\] VGND VGND VPWR VPWR _2843_ sky130_fd_sc_hd__clkbuf_1
Xclkbuf_leaf_6_clk clknet_1_1__leaf_clk VGND VGND VPWR VPWR clknet_leaf_6_clk sky130_fd_sc_hd__clkbuf_8
X_3444_ _0660_ _0661_ _0585_ VGND VGND VPWR VPWR _1109_ sky130_fd_sc_hd__a21o_1
X_3513_ _1153_ _1176_ _1177_ VGND VGND VPWR VPWR _1178_ sky130_fd_sc_hd__a21oi_1
X_4562_ _0814_ _0821_ VGND VGND VPWR VPWR _2186_ sky130_fd_sc_hd__and2b_1
X_4493_ _2110_ _2122_ VGND VGND VPWR VPWR _2123_ sky130_fd_sc_hd__or2_1
X_6232_ clknet_leaf_0_clk _0467_ VGND VGND VPWR VPWR reg_file.memory\[2\]\[6\] sky130_fd_sc_hd__dfxtp_1
XFILLER_0_8_46 VGND VGND VPWR VPWR sky130_fd_sc_hd__fill_1
X_6094_ clknet_leaf_9_clk _0329_ VGND VGND VPWR VPWR reg_file.memory\[10\]\[28\] sky130_fd_sc_hd__dfxtp_1
X_5045_ _2508_ VGND VGND VPWR VPWR _0171_ sky130_fd_sc_hd__clkbuf_1
X_5114_ _2545_ VGND VGND VPWR VPWR _0203_ sky130_fd_sc_hd__clkbuf_1
X_6163_ clknet_leaf_3_clk _0398_ VGND VGND VPWR VPWR reg_file.memory\[21\]\[1\] sky130_fd_sc_hd__dfxtp_1
X_3375_ reg_file.memory\[5\]\[7\] _1039_ _0645_ VGND VGND VPWR VPWR _1040_ sky130_fd_sc_hd__mux2_1
XFILLER_0_79_279 VGND VGND VPWR VPWR sky130_fd_sc_hd__fill_1
X_5947_ clknet_leaf_23_clk _0182_ VGND VGND VPWR VPWR reg_file.memory\[6\]\[9\] sky130_fd_sc_hd__dfxtp_1
X_5878_ clknet_leaf_1_clk _0113_ VGND VGND VPWR VPWR reg_file.memory\[4\]\[4\] sky130_fd_sc_hd__dfxtp_1
X_4829_ _2378_ VGND VGND VPWR VPWR _0085_ sky130_fd_sc_hd__clkbuf_1
XFILLER_0_53_135 VGND VGND VPWR VPWR sky130_fd_sc_hd__fill_2
XFILLER_0_53_113 VGND VGND VPWR VPWR sky130_fd_sc_hd__decap_4
XPHY_EDGE_ROW_89_Left_180 VGND VGND VPWR VPWR sky130_fd_sc_hd__decap_3
XTAP_TAPCELL_ROW_77_653 VGND VPWR sky130_fd_sc_hd__tapvpwrvgnd_1
X_3091_ _0747_ _0754_ VGND VGND VPWR VPWR _0756_ sky130_fd_sc_hd__and2_1
X_3160_ reg_file.memory\[0\]\[20\] reg_file.memory\[1\]\[20\] _0593_ VGND VGND VPWR
+ VPWR _0825_ sky130_fd_sc_hd__mux2_1
X_5732_ _0020_ _2292_ _2868_ net6 _2296_ VGND VGND VPWR VPWR _0498_ sky130_fd_sc_hd__o32a_1
XFILLER_0_76_227 VGND VGND VPWR VPWR sky130_fd_sc_hd__fill_2
XFILLER_0_76_205 VGND VGND VPWR VPWR sky130_fd_sc_hd__fill_2
XFILLER_0_69_290 VGND VGND VPWR VPWR sky130_fd_sc_hd__fill_2
X_5801_ _0534_ _0014_ VGND VGND VPWR VPWR alu.ALUResult\[7\] sky130_fd_sc_hd__dlxtn_1
X_3993_ _0016_ _1641_ _1642_ _1643_ VGND VGND VPWR VPWR _0002_ sky130_fd_sc_hd__o22a_1
XPHY_EDGE_ROW_8_Right_8 VGND VGND VPWR VPWR sky130_fd_sc_hd__decap_3
X_2875_ PC\[2\] VGND VGND VPWR VPWR _0540_ sky130_fd_sc_hd__buf_2
X_4545_ _2150_ _2170_ _1779_ VGND VGND VPWR VPWR _2171_ sky130_fd_sc_hd__mux2_1
X_5594_ _2411_ reg_file.memory\[25\]\[1\] _2797_ VGND VGND VPWR VPWR _2799_ sky130_fd_sc_hd__mux2_1
X_2944_ _0547_ _0548_ _0550_ VGND VGND VPWR VPWR _0609_ sky130_fd_sc_hd__or3_2
X_4614_ _1963_ _2211_ _2233_ _1816_ VGND VGND VPWR VPWR _2234_ sky130_fd_sc_hd__a211oi_1
X_5663_ _2834_ VGND VGND VPWR VPWR _0463_ sky130_fd_sc_hd__clkbuf_1
XTAP_TAPCELL_ROW_60_553 VGND VPWR sky130_fd_sc_hd__tapvpwrvgnd_1
X_4476_ _2001_ _2100_ _2107_ _2041_ VGND VGND VPWR VPWR _2108_ sky130_fd_sc_hd__o211a_1
XPHY_EDGE_ROW_39_Right_39 VGND VGND VPWR VPWR sky130_fd_sc_hd__decap_3
X_6215_ clknet_leaf_15_clk _0450_ VGND VGND VPWR VPWR reg_file.memory\[25\]\[21\]
+ sky130_fd_sc_hd__dfxtp_1
X_3427_ reg_file.memory\[6\]\[4\] reg_file.memory\[7\]\[4\] _0635_ VGND VGND VPWR
+ VPWR _1092_ sky130_fd_sc_hd__mux2_1
X_3358_ reg_file.memory\[6\]\[8\] reg_file.memory\[7\]\[8\] _0636_ VGND VGND VPWR
+ VPWR _1023_ sky130_fd_sc_hd__mux2_1
X_6146_ clknet_leaf_19_clk _0381_ VGND VGND VPWR VPWR reg_file.memory\[1\]\[16\] sky130_fd_sc_hd__dfxtp_1
XFILLER_0_67_205 VGND VGND VPWR VPWR sky130_fd_sc_hd__decap_4
X_5028_ _2455_ reg_file.memory\[5\]\[22\] _2497_ VGND VGND VPWR VPWR _2500_ sky130_fd_sc_hd__mux2_1
X_6077_ clknet_leaf_25_clk _0312_ VGND VGND VPWR VPWR reg_file.memory\[10\]\[11\]
+ sky130_fd_sc_hd__dfxtp_1
X_3289_ reg_file.memory\[0\]\[12\] reg_file.memory\[1\]\[12\] _0591_ VGND VGND VPWR
+ VPWR _0954_ sky130_fd_sc_hd__mux2_1
XTAP_TAPCELL_ROW_83_689 VGND VPWR sky130_fd_sc_hd__tapvpwrvgnd_1
XFILLER_0_75_293 VGND VGND VPWR VPWR sky130_fd_sc_hd__fill_1
XPHY_EDGE_ROW_48_Right_48 VGND VGND VPWR VPWR sky130_fd_sc_hd__decap_3
XTAP_TAPCELL_ROW_0_186 VGND VPWR sky130_fd_sc_hd__tapvpwrvgnd_1
XPHY_EDGE_ROW_57_Right_57 VGND VGND VPWR VPWR sky130_fd_sc_hd__decap_3
XFILLER_0_35_179 VGND VGND VPWR VPWR sky130_fd_sc_hd__fill_1
XTAP_TAPCELL_ROW_74_634 VGND VPWR sky130_fd_sc_hd__tapvpwrvgnd_1
XPHY_EDGE_ROW_66_Right_66 VGND VGND VPWR VPWR sky130_fd_sc_hd__decap_3
XFILLER_0_58_205 VPWR VGND VPWR VGND sky130_ef_sc_hd__decap_12
XFILLER_0_41_127 VGND VGND VPWR VPWR sky130_fd_sc_hd__fill_1
XTAP_TAPCELL_ROW_14_277 VGND VPWR sky130_fd_sc_hd__tapvpwrvgnd_1
XPHY_EDGE_ROW_75_Right_75 VGND VGND VPWR VPWR sky130_fd_sc_hd__decap_3
X_6000_ clknet_leaf_11_clk _0235_ VGND VGND VPWR VPWR reg_file.memory\[7\]\[30\] sky130_fd_sc_hd__dfxtp_1
X_4330_ _1940_ _1970_ VGND VGND VPWR VPWR _1971_ sky130_fd_sc_hd__nor2_1
X_4261_ _1177_ _1155_ _1874_ VGND VGND VPWR VPWR _1905_ sky130_fd_sc_hd__or3_1
X_3212_ reg_file.memory\[21\]\[17\] _0545_ _0625_ _0876_ VGND VGND VPWR VPWR _0877_
+ sky130_fd_sc_hd__o211ai_2
XFILLER_0_22_363 VGND VGND VPWR VPWR sky130_fd_sc_hd__fill_1
XPHY_EDGE_ROW_84_Right_84 VGND VGND VPWR VPWR sky130_fd_sc_hd__decap_3
X_4192_ _1659_ _1760_ VGND VGND VPWR VPWR _1837_ sky130_fd_sc_hd__nand2_1
X_3074_ reg_file.memory\[2\]\[25\] _0567_ _0575_ reg_file.memory\[7\]\[25\] _0581_
+ VGND VGND VPWR VPWR _0739_ sky130_fd_sc_hd__o221a_1
XFILLER_0_66_88 VGND VGND VPWR VPWR sky130_fd_sc_hd__decap_3
X_3143_ reg_file.memory\[4\]\[21\] reg_file.memory\[5\]\[21\] _0594_ VGND VGND VPWR
+ VPWR _0808_ sky130_fd_sc_hd__mux2_1
X_5715_ _2860_ VGND VGND VPWR VPWR _0489_ sky130_fd_sc_hd__clkbuf_1
X_3976_ _1630_ VGND VGND VPWR VPWR _0018_ sky130_fd_sc_hd__buf_6
XFILLER_0_9_335 VGND VGND VPWR VPWR sky130_fd_sc_hd__fill_1
XFILLER_0_17_113 VGND VGND VPWR VPWR sky130_fd_sc_hd__fill_2
X_2927_ _0591_ VGND VGND VPWR VPWR _0592_ sky130_fd_sc_hd__clkbuf_4
X_5646_ _2463_ reg_file.memory\[25\]\[26\] _2819_ VGND VGND VPWR VPWR _2826_ sky130_fd_sc_hd__mux2_1
X_5577_ _2463_ reg_file.memory\[21\]\[26\] _2782_ VGND VGND VPWR VPWR _2789_ sky130_fd_sc_hd__mux2_1
X_4528_ _1907_ _2148_ _2149_ _2155_ VGND VGND VPWR VPWR _0514_ sky130_fd_sc_hd__a211o_1
XFILLER_0_40_171 VGND VGND VPWR VPWR sky130_fd_sc_hd__fill_2
X_6129_ clknet_leaf_13_clk _0364_ VGND VGND VPWR VPWR reg_file.memory\[15\]\[31\]
+ sky130_fd_sc_hd__dfxtp_1
X_4459_ _0959_ _0966_ VGND VGND VPWR VPWR _2092_ sky130_fd_sc_hd__and2b_1
XTAP_TAPCELL_ROW_5_223 VGND VPWR sky130_fd_sc_hd__tapvpwrvgnd_1
XTAP_TAPCELL_ROW_71_615 VGND VPWR sky130_fd_sc_hd__tapvpwrvgnd_1
XTAP_TAPCELL_ROW_28_358 VGND VPWR sky130_fd_sc_hd__tapvpwrvgnd_1
XTAP_TAPCELL_ROW_11_258 VGND VPWR sky130_fd_sc_hd__tapvpwrvgnd_1
XTAP_TAPCELL_ROW_19_303 VGND VPWR sky130_fd_sc_hd__tapvpwrvgnd_1
X_3830_ _1477_ _1485_ VGND VGND VPWR VPWR _1486_ sky130_fd_sc_hd__or2_1
XFILLER_0_6_305 VGND VGND VPWR VPWR sky130_fd_sc_hd__decap_3
X_3761_ _1370_ _1413_ _1415_ VGND VGND VPWR VPWR _1417_ sky130_fd_sc_hd__and3_1
X_5500_ reg_file.memory\[1\]\[22\] VGND VGND VPWR VPWR _2748_ sky130_fd_sc_hd__clkbuf_1
X_5431_ _2690_ VGND VGND VPWR VPWR _2713_ sky130_fd_sc_hd__clkbuf_4
X_5362_ _2653_ VGND VGND VPWR VPWR _2676_ sky130_fd_sc_hd__buf_4
X_3692_ _1344_ VGND VGND VPWR VPWR _1349_ sky130_fd_sc_hd__inv_2
X_4244_ _1658_ _1884_ _1887_ _1708_ VGND VGND VPWR VPWR _1888_ sky130_fd_sc_hd__o22ai_2
X_4175_ _1710_ _1721_ VGND VGND VPWR VPWR _1820_ sky130_fd_sc_hd__nand2_1
XFILLER_0_77_87 VGND VGND VPWR VPWR sky130_fd_sc_hd__decap_3
X_4313_ _1108_ _1118_ VGND VGND VPWR VPWR _1955_ sky130_fd_sc_hd__nor2_1
XTAP_TAPCELL_ROW_2_204 VGND VPWR sky130_fd_sc_hd__tapvpwrvgnd_1
X_5293_ reg_file.memory\[0\]\[19\] VGND VGND VPWR VPWR _2640_ sky130_fd_sc_hd__clkbuf_1
X_3126_ reg_file.memory\[7\]\[22\] _0674_ _0601_ reg_file.memory\[2\]\[22\] _0581_
+ VGND VGND VPWR VPWR _0791_ sky130_fd_sc_hd__o221a_1
X_3057_ reg_file.memory\[7\]\[26\] _0674_ _0600_ reg_file.memory\[2\]\[26\] _0580_
+ VGND VGND VPWR VPWR _0722_ sky130_fd_sc_hd__o221a_1
XTAP_TAPCELL_ROW_25_339 VGND VPWR sky130_fd_sc_hd__tapvpwrvgnd_1
XFILLER_0_42_90 VGND VGND VPWR VPWR sky130_fd_sc_hd__fill_2
X_3959_ _1597_ _1606_ VGND VGND VPWR VPWR _1615_ sky130_fd_sc_hd__xnor2_1
X_5629_ _2446_ reg_file.memory\[25\]\[18\] _2808_ VGND VGND VPWR VPWR _2817_ sky130_fd_sc_hd__mux2_1
XFILLER_0_22_38 VGND VGND VPWR VPWR sky130_fd_sc_hd__decap_4
XPHY_EDGE_ROW_16_Left_107 VGND VGND VPWR VPWR sky130_fd_sc_hd__decap_3
XTAP_TAPCELL_ROW_90_732 VGND VPWR sky130_fd_sc_hd__tapvpwrvgnd_1
XTAP_TAPCELL_ROW_47_475 VGND VPWR sky130_fd_sc_hd__tapvpwrvgnd_1
X_5980_ clknet_leaf_23_clk _0215_ VGND VGND VPWR VPWR reg_file.memory\[7\]\[10\] sky130_fd_sc_hd__dfxtp_1
X_4931_ _2441_ VGND VGND VPWR VPWR _0124_ sky130_fd_sc_hd__clkbuf_1
XFILLER_0_86_174 VGND VGND VPWR VPWR sky130_fd_sc_hd__fill_2
X_4862_ reg_file.memory\[9\]\[26\] VGND VGND VPWR VPWR _2395_ sky130_fd_sc_hd__clkbuf_1
XFILLER_0_42_211 VGND VGND VPWR VPWR sky130_fd_sc_hd__fill_2
X_3744_ _1397_ _1399_ _1394_ VGND VGND VPWR VPWR _1400_ sky130_fd_sc_hd__a21oi_1
XPHY_EDGE_ROW_25_Left_116 VGND VGND VPWR VPWR sky130_fd_sc_hd__decap_3
X_3813_ _1457_ _1463_ VGND VGND VPWR VPWR _1469_ sky130_fd_sc_hd__or2b_1
XFILLER_0_6_124 VGND VGND VPWR VPWR sky130_fd_sc_hd__decap_3
XFILLER_0_6_157 VGND VGND VPWR VPWR sky130_fd_sc_hd__decap_6
X_4793_ _1445_ VGND VGND VPWR VPWR _2360_ sky130_fd_sc_hd__inv_2
X_3675_ _1335_ VGND VGND VPWR VPWR _0008_ sky130_fd_sc_hd__clkbuf_1
XFILLER_0_56_3 VGND VGND VPWR VPWR sky130_fd_sc_hd__fill_1
X_5414_ _2704_ VGND VGND VPWR VPWR _0344_ sky130_fd_sc_hd__clkbuf_1
XPHY_EDGE_ROW_34_Left_125 VGND VGND VPWR VPWR sky130_fd_sc_hd__decap_3
XFILLER_0_6_179 VGND VGND VPWR VPWR sky130_fd_sc_hd__decap_8
XFILLER_0_10_130 VGND VGND VPWR VPWR sky130_fd_sc_hd__fill_1
X_5345_ _2667_ VGND VGND VPWR VPWR _0312_ sky130_fd_sc_hd__clkbuf_1
X_4158_ _1801_ _1802_ VGND VGND VPWR VPWR _1803_ sky130_fd_sc_hd__nand2_1
X_4227_ _1157_ _1175_ VGND VGND VPWR VPWR _1872_ sky130_fd_sc_hd__or2_1
XTAP_TAPCELL_ROW_38_420 VGND VPWR sky130_fd_sc_hd__tapvpwrvgnd_1
X_5276_ _2631_ VGND VGND VPWR VPWR _0279_ sky130_fd_sc_hd__clkbuf_1
X_4089_ _1658_ _1705_ _1708_ _1734_ VGND VGND VPWR VPWR _1735_ sky130_fd_sc_hd__o22a_1
X_3109_ _0772_ _0773_ VGND VGND VPWR VPWR _0774_ sky130_fd_sc_hd__nand2_1
XPHY_EDGE_ROW_43_Left_134 VGND VGND VPWR VPWR sky130_fd_sc_hd__decap_3
XPHY_EDGE_ROW_52_Left_143 VGND VGND VPWR VPWR sky130_fd_sc_hd__decap_3
XPHY_EDGE_ROW_61_Left_152 VGND VGND VPWR VPWR sky130_fd_sc_hd__decap_3
XFILLER_0_83_111 VGND VGND VPWR VPWR sky130_fd_sc_hd__fill_1
XFILLER_0_83_100 VGND VGND VPWR VPWR sky130_fd_sc_hd__fill_2
XFILLER_0_68_141 VGND VGND VPWR VPWR sky130_fd_sc_hd__decap_4
XTAP_TAPCELL_ROW_44_456 VGND VPWR sky130_fd_sc_hd__tapvpwrvgnd_1
XPHY_EDGE_ROW_70_Left_161 VGND VGND VPWR VPWR sky130_fd_sc_hd__decap_3
X_3460_ reg_file.memory\[15\]\[2\] _0551_ _0615_ _1124_ VGND VGND VPWR VPWR _1125_
+ sky130_fd_sc_hd__a211o_1
X_3391_ _1047_ _0616_ _1053_ _1054_ _1055_ VGND VGND VPWR VPWR _1056_ sky130_fd_sc_hd__a221o_1
X_4012_ _1657_ VGND VGND VPWR VPWR _1658_ sky130_fd_sc_hd__clkbuf_4
XFILLER_0_42_9 VGND VGND VPWR VPWR sky130_fd_sc_hd__fill_1
X_5130_ _2554_ VGND VGND VPWR VPWR _0210_ sky130_fd_sc_hd__clkbuf_1
X_5061_ _2419_ reg_file.memory\[6\]\[5\] _2512_ VGND VGND VPWR VPWR _2518_ sky130_fd_sc_hd__mux2_1
XFILLER_0_90_32 VGND VGND VPWR VPWR sky130_fd_sc_hd__decap_6
X_5963_ clknet_leaf_11_clk _0198_ VGND VGND VPWR VPWR reg_file.memory\[6\]\[25\] sky130_fd_sc_hd__dfxtp_1
X_5894_ clknet_leaf_15_clk _0129_ VGND VGND VPWR VPWR reg_file.memory\[4\]\[20\] sky130_fd_sc_hd__dfxtp_1
XTAP_TAPCELL_ROW_35_401 VGND VPWR sky130_fd_sc_hd__tapvpwrvgnd_1
X_4914_ _2408_ VGND VGND VPWR VPWR _2430_ sky130_fd_sc_hd__clkbuf_4
XFILLER_0_62_306 VGND VGND VPWR VPWR sky130_fd_sc_hd__fill_2
X_3727_ _1373_ _1381_ _1382_ VGND VGND VPWR VPWR _1383_ sky130_fd_sc_hd__or3_1
X_4776_ _2340_ _1514_ _2351_ VGND VGND VPWR VPWR _0059_ sky130_fd_sc_hd__o21ai_1
X_4845_ _2386_ VGND VGND VPWR VPWR _0093_ sky130_fd_sc_hd__clkbuf_1
X_3589_ reg_file.memory\[5\]\[31\] _1253_ _0650_ VGND VGND VPWR VPWR _1254_ sky130_fd_sc_hd__mux2_1
X_3658_ _1241_ _1322_ VGND VGND VPWR VPWR _1323_ sky130_fd_sc_hd__nand2_1
X_5328_ _2658_ VGND VGND VPWR VPWR _0304_ sky130_fd_sc_hd__clkbuf_1
XTAP_TAPCELL_ROW_58_537 VGND VPWR sky130_fd_sc_hd__tapvpwrvgnd_1
X_5259_ reg_file.memory\[0\]\[2\] VGND VGND VPWR VPWR _2623_ sky130_fd_sc_hd__clkbuf_1
XFILLER_0_65_133 VGND VGND VPWR VPWR sky130_fd_sc_hd__fill_1
XTAP_TAPCELL_ROW_41_437 VGND VPWR sky130_fd_sc_hd__tapvpwrvgnd_1
XPHY_EDGE_ROW_5_Left_96 VGND VGND VPWR VPWR sky130_fd_sc_hd__decap_3
XFILLER_0_21_225 VGND VGND VPWR VPWR sky130_fd_sc_hd__fill_1
X_2960_ _0624_ VGND VGND VPWR VPWR _0625_ sky130_fd_sc_hd__clkbuf_8
X_4630_ _1779_ _1717_ _1722_ VGND VGND VPWR VPWR _2248_ sky130_fd_sc_hd__and3_1
X_2891_ _0549_ _0555_ VGND VGND VPWR VPWR _0556_ sky130_fd_sc_hd__nor2_1
X_4561_ _1797_ _2180_ _2181_ _2185_ VGND VGND VPWR VPWR _0518_ sky130_fd_sc_hd__a211o_1
XFILLER_0_69_77 VGND VGND VPWR VPWR sky130_fd_sc_hd__fill_2
XFILLER_0_69_55 VGND VGND VPWR VPWR sky130_fd_sc_hd__fill_1
X_5113_ _2471_ reg_file.memory\[6\]\[30\] _2511_ VGND VGND VPWR VPWR _2545_ sky130_fd_sc_hd__mux2_1
X_3512_ _1128_ _1137_ VGND VGND VPWR VPWR _1177_ sky130_fd_sc_hd__xnor2_1
X_3443_ _1107_ VGND VGND VPWR VPWR _1108_ sky130_fd_sc_hd__inv_2
X_6162_ clknet_leaf_3_clk _0397_ VGND VGND VPWR VPWR reg_file.memory\[21\]\[0\] sky130_fd_sc_hd__dfxtp_1
X_4492_ _0911_ _0918_ VGND VGND VPWR VPWR _2122_ sky130_fd_sc_hd__and2b_1
X_6231_ clknet_leaf_0_clk _0466_ VGND VGND VPWR VPWR reg_file.memory\[2\]\[5\] sky130_fd_sc_hd__dfxtp_1
X_3374_ reg_file.memory\[6\]\[7\] reg_file.memory\[7\]\[7\] _0636_ VGND VGND VPWR
+ VPWR _1039_ sky130_fd_sc_hd__mux2_1
X_6093_ clknet_leaf_9_clk _0328_ VGND VGND VPWR VPWR reg_file.memory\[10\]\[27\] sky130_fd_sc_hd__dfxtp_1
XFILLER_0_79_225 VGND VGND VPWR VPWR sky130_fd_sc_hd__decap_3
X_5044_ _2471_ reg_file.memory\[5\]\[30\] _2474_ VGND VGND VPWR VPWR _2508_ sky130_fd_sc_hd__mux2_1
XTAP_TAPCELL_ROW_55_518 VGND VPWR sky130_fd_sc_hd__tapvpwrvgnd_1
XFILLER_0_47_144 VPWR VGND VPWR VGND sky130_ef_sc_hd__decap_12
X_5877_ clknet_leaf_1_clk _0112_ VGND VGND VPWR VPWR reg_file.memory\[4\]\[3\] sky130_fd_sc_hd__dfxtp_1
X_5946_ clknet_leaf_2_clk _0181_ VGND VGND VPWR VPWR reg_file.memory\[6\]\[8\] sky130_fd_sc_hd__dfxtp_1
X_4828_ reg_file.memory\[9\]\[9\] VGND VGND VPWR VPWR _2378_ sky130_fd_sc_hd__clkbuf_1
XFILLER_0_50_309 VGND VGND VPWR VPWR sky130_fd_sc_hd__fill_1
X_4759_ _1574_ _1577_ _2341_ VGND VGND VPWR VPWR _2342_ sky130_fd_sc_hd__a21oi_1
XFILLER_0_53_169 VGND VGND VPWR VPWR sky130_fd_sc_hd__decap_8
XFILLER_0_53_158 VGND VGND VPWR VPWR sky130_fd_sc_hd__decap_8
XTAP_TAPCELL_ROW_77_654 VGND VPWR sky130_fd_sc_hd__tapvpwrvgnd_1
X_3090_ _0747_ _0754_ VGND VGND VPWR VPWR _0755_ sky130_fd_sc_hd__nor2_1
X_5731_ _1344_ seven_seg_conv.digit_counter\[2\] VGND VGND VPWR VPWR _2868_ sky130_fd_sc_hd__or2_1
X_2943_ _0575_ _0596_ _0603_ _0607_ VGND VGND VPWR VPWR _0608_ sky130_fd_sc_hd__o211a_1
XFILLER_0_71_89 VGND VGND VPWR VPWR sky130_fd_sc_hd__decap_4
X_5800_ _0533_ _0014_ VGND VGND VPWR VPWR alu.ALUResult\[6\] sky130_fd_sc_hd__dlxtn_1
X_3992_ _0019_ VGND VGND VPWR VPWR _1643_ sky130_fd_sc_hd__inv_2
XFILLER_0_17_317 VGND VGND VPWR VPWR sky130_fd_sc_hd__fill_2
X_2874_ PC\[0\] VGND VGND VPWR VPWR _0539_ sky130_fd_sc_hd__inv_2
X_4544_ _1684_ _1691_ VGND VGND VPWR VPWR _2170_ sky130_fd_sc_hd__nand2_1
X_4613_ _1719_ _1724_ _1727_ VGND VGND VPWR VPWR _2233_ sky130_fd_sc_hd__and3_1
X_5662_ reg_file.memory\[2\]\[2\] VGND VGND VPWR VPWR _2834_ sky130_fd_sc_hd__clkbuf_1
X_5593_ _2798_ VGND VGND VPWR VPWR _0429_ sky130_fd_sc_hd__clkbuf_1
X_4475_ _1743_ _2105_ _2106_ VGND VGND VPWR VPWR _2107_ sky130_fd_sc_hd__or3b_1
X_3357_ reg_file.memory\[21\]\[8\] _0544_ _0624_ _1021_ VGND VGND VPWR VPWR _1022_
+ sky130_fd_sc_hd__o211ai_2
X_3426_ _1083_ _0615_ _1089_ _1090_ _1055_ VGND VGND VPWR VPWR _1091_ sky130_fd_sc_hd__a221o_4
X_6214_ clknet_leaf_15_clk _0449_ VGND VGND VPWR VPWR reg_file.memory\[25\]\[20\]
+ sky130_fd_sc_hd__dfxtp_1
X_6076_ clknet_leaf_25_clk _0311_ VGND VGND VPWR VPWR reg_file.memory\[10\]\[10\]
+ sky130_fd_sc_hd__dfxtp_1
X_6145_ clknet_leaf_20_clk _0380_ VGND VGND VPWR VPWR reg_file.memory\[1\]\[15\] sky130_fd_sc_hd__dfxtp_1
X_5027_ _2499_ VGND VGND VPWR VPWR _0162_ sky130_fd_sc_hd__clkbuf_1
XTAP_TAPCELL_ROW_0_187 VGND VPWR sky130_fd_sc_hd__tapvpwrvgnd_1
X_3288_ reg_file.memory\[4\]\[12\] reg_file.memory\[5\]\[12\] _0591_ VGND VGND VPWR
+ VPWR _0953_ sky130_fd_sc_hd__mux2_1
X_5929_ clknet_leaf_10_clk _0164_ VGND VGND VPWR VPWR reg_file.memory\[5\]\[23\] sky130_fd_sc_hd__dfxtp_1
XFILLER_0_0_92 VGND VGND VPWR VPWR sky130_fd_sc_hd__fill_1
XFILLER_0_50_139 VGND VGND VPWR VPWR sky130_fd_sc_hd__fill_1
XFILLER_0_31_342 VGND VGND VPWR VPWR sky130_fd_sc_hd__fill_1
XFILLER_0_8_3 VGND VGND VPWR VPWR sky130_fd_sc_hd__decap_4
XTAP_TAPCELL_ROW_74_635 VGND VPWR sky130_fd_sc_hd__tapvpwrvgnd_1
XFILLER_0_58_217 VPWR VGND VPWR VGND sky130_ef_sc_hd__decap_12
X_4191_ _1786_ _1832_ _1833_ _1834_ _1835_ VGND VGND VPWR VPWR _1836_ sky130_fd_sc_hd__a32o_1
X_4260_ _1155_ _1874_ _1177_ VGND VGND VPWR VPWR _1904_ sky130_fd_sc_hd__o21ai_1
X_3142_ reg_file.memory\[2\]\[21\] _0567_ _0574_ reg_file.memory\[7\]\[21\] _0581_
+ VGND VGND VPWR VPWR _0807_ sky130_fd_sc_hd__o221a_1
X_3211_ reg_file.memory\[15\]\[17\] _0553_ _0617_ _0875_ VGND VGND VPWR VPWR _0876_
+ sky130_fd_sc_hd__a211o_1
XFILLER_0_5_15 VGND VGND VPWR VPWR sky130_fd_sc_hd__decap_4
XFILLER_0_82_44 VGND VGND VPWR VPWR sky130_fd_sc_hd__decap_8
XFILLER_0_82_33 VGND VGND VPWR VPWR sky130_fd_sc_hd__fill_1
XFILLER_0_82_11 VGND VGND VPWR VPWR sky130_fd_sc_hd__fill_2
X_3073_ _0730_ _0737_ VGND VGND VPWR VPWR _0738_ sky130_fd_sc_hd__nand2_1
X_5714_ reg_file.memory\[2\]\[28\] VGND VGND VPWR VPWR _2860_ sky130_fd_sc_hd__clkbuf_1
X_5645_ _2825_ VGND VGND VPWR VPWR _0454_ sky130_fd_sc_hd__clkbuf_1
X_2926_ _0590_ VGND VGND VPWR VPWR _0591_ sky130_fd_sc_hd__clkbuf_4
X_3975_ _1627_ _1629_ _1349_ seven_seg_conv.current_digit\[2\] VGND VGND VPWR VPWR
+ _1630_ sky130_fd_sc_hd__o2bb2a_1
XFILLER_0_15_82 VGND VGND VPWR VPWR sky130_fd_sc_hd__fill_1
XFILLER_0_72_297 VGND VGND VPWR VPWR sky130_fd_sc_hd__fill_2
X_5576_ _2788_ VGND VGND VPWR VPWR _0422_ sky130_fd_sc_hd__clkbuf_1
X_4527_ _1976_ _1881_ _2154_ _2041_ VGND VGND VPWR VPWR _2155_ sky130_fd_sc_hd__o211a_1
X_4458_ _1278_ _2059_ VGND VGND VPWR VPWR _2091_ sky130_fd_sc_hd__nor2_1
XTAP_TAPCELL_ROW_88_716 VGND VPWR sky130_fd_sc_hd__tapvpwrvgnd_1
X_4389_ _1705_ _1707_ _1766_ _1889_ VGND VGND VPWR VPWR _2027_ sky130_fd_sc_hd__o22a_1
X_6059_ clknet_leaf_11_clk _0294_ VGND VGND VPWR VPWR reg_file.memory\[0\]\[25\] sky130_fd_sc_hd__dfxtp_1
X_6128_ clknet_leaf_13_clk _0363_ VGND VGND VPWR VPWR reg_file.memory\[15\]\[30\]
+ sky130_fd_sc_hd__dfxtp_1
X_3409_ reg_file.memory\[5\]\[5\] _1073_ _0645_ VGND VGND VPWR VPWR _1074_ sky130_fd_sc_hd__mux2_1
XTAP_TAPCELL_ROW_71_616 VGND VPWR sky130_fd_sc_hd__tapvpwrvgnd_1
XTAP_TAPCELL_ROW_28_359 VGND VPWR sky130_fd_sc_hd__tapvpwrvgnd_1
XFILLER_0_48_294 VGND VGND VPWR VPWR sky130_fd_sc_hd__decap_6
XFILLER_0_48_283 VGND VGND VPWR VPWR sky130_fd_sc_hd__fill_2
XTAP_TAPCELL_ROW_11_259 VGND VPWR sky130_fd_sc_hd__tapvpwrvgnd_1
XFILLER_0_36_48 VGND VGND VPWR VPWR sky130_fd_sc_hd__fill_2
XTAP_TAPCELL_ROW_19_304 VGND VPWR sky130_fd_sc_hd__tapvpwrvgnd_1
XFILLER_0_54_253 VGND VGND VPWR VPWR sky130_fd_sc_hd__decap_6
XFILLER_0_39_250 VGND VGND VPWR VPWR sky130_fd_sc_hd__decap_3
XFILLER_0_6_317 VGND VGND VPWR VPWR sky130_fd_sc_hd__decap_3
X_3760_ _1413_ _1415_ _1370_ VGND VGND VPWR VPWR _1416_ sky130_fd_sc_hd__a21oi_1
XFILLER_0_77_55 VGND VGND VPWR VPWR sky130_fd_sc_hd__fill_1
X_4312_ _1794_ VGND VGND VPWR VPWR _1954_ sky130_fd_sc_hd__clkbuf_4
XFILLER_0_54_275 VGND VGND VPWR VPWR sky130_fd_sc_hd__fill_1
X_3691_ seven_seg_conv.temp\[0\] alu.ALUResult\[0\] _1347_ VGND VGND VPWR VPWR _1348_
+ sky130_fd_sc_hd__mux2_1
X_5361_ _2675_ VGND VGND VPWR VPWR _0320_ sky130_fd_sc_hd__clkbuf_1
XFILLER_0_14_139 VGND VGND VPWR VPWR sky130_fd_sc_hd__fill_1
X_5292_ _2639_ VGND VGND VPWR VPWR _0287_ sky130_fd_sc_hd__clkbuf_1
XFILLER_0_22_194 VGND VGND VPWR VPWR sky130_fd_sc_hd__fill_2
X_5430_ _2712_ VGND VGND VPWR VPWR _0352_ sky130_fd_sc_hd__clkbuf_1
X_4243_ _1885_ _1886_ _1733_ VGND VGND VPWR VPWR _1887_ sky130_fd_sc_hd__mux2_1
X_4174_ _1701_ VGND VGND VPWR VPWR _1819_ sky130_fd_sc_hd__clkbuf_4
XFILLER_0_77_99 VGND VGND VPWR VPWR sky130_fd_sc_hd__fill_1
X_3125_ _0782_ _0789_ VGND VGND VPWR VPWR _0790_ sky130_fd_sc_hd__nor2_1
XTAP_TAPCELL_ROW_2_205 VGND VPWR sky130_fd_sc_hd__tapvpwrvgnd_1
XFILLER_0_89_183 VPWR VGND VPWR VGND sky130_ef_sc_hd__decap_12
X_3056_ reg_file.memory\[25\]\[27\] _0720_ _0671_ VGND VGND VPWR VPWR _0721_ sky130_fd_sc_hd__mux2_2
X_5628_ _2816_ VGND VGND VPWR VPWR _0446_ sky130_fd_sc_hd__clkbuf_1
X_3958_ _1354_ _1604_ _1610_ _1613_ _1353_ VGND VGND VPWR VPWR _1614_ sky130_fd_sc_hd__a311o_1
XFILLER_0_5_350 VPWR VGND VPWR VGND sky130_ef_sc_hd__decap_12
X_3889_ _1360_ _1540_ _1544_ _1358_ VGND VGND VPWR VPWR _1545_ sky130_fd_sc_hd__o211ai_2
X_2909_ _0573_ VGND VGND VPWR VPWR _0574_ sky130_fd_sc_hd__buf_2
X_5559_ _2779_ VGND VGND VPWR VPWR _0414_ sky130_fd_sc_hd__clkbuf_1
XFILLER_0_68_312 VGND VGND VPWR VPWR sky130_fd_sc_hd__fill_1
XFILLER_0_83_337 VGND VGND VPWR VPWR sky130_fd_sc_hd__fill_2
XTAP_TAPCELL_ROW_90_733 VGND VPWR sky130_fd_sc_hd__tapvpwrvgnd_1
X_4861_ _2394_ VGND VGND VPWR VPWR _0101_ sky130_fd_sc_hd__clkbuf_1
XFILLER_0_86_164 VGND VGND VPWR VPWR sky130_fd_sc_hd__fill_1
XFILLER_0_78_109 VGND VGND VPWR VPWR sky130_fd_sc_hd__decap_3
XFILLER_0_63_68 VGND VGND VPWR VPWR sky130_fd_sc_hd__fill_2
X_4930_ _2440_ reg_file.memory\[4\]\[15\] _2430_ VGND VGND VPWR VPWR _2441_ sky130_fd_sc_hd__mux2_1
X_3674_ _0562_ _1334_ ctrl_unit.PCWrite VGND VGND VPWR VPWR _1335_ sky130_fd_sc_hd__mux2_1
XFILLER_0_74_326 VGND VGND VPWR VPWR sky130_fd_sc_hd__fill_1
X_3743_ _1398_ _1383_ _1386_ VGND VGND VPWR VPWR _1399_ sky130_fd_sc_hd__mux2_1
X_3812_ seven_seg_conv.temp\[18\] alu.ALUResult\[18\] _1346_ VGND VGND VPWR VPWR _1468_
+ sky130_fd_sc_hd__mux2_1
X_4792_ _2359_ VGND VGND VPWR VPWR _0067_ sky130_fd_sc_hd__clkbuf_1
XFILLER_0_42_289 VGND VGND VPWR VPWR sky130_fd_sc_hd__decap_4
X_5413_ _2432_ reg_file.memory\[15\]\[11\] _2702_ VGND VGND VPWR VPWR _2704_ sky130_fd_sc_hd__mux2_1
X_5344_ reg_file.memory\[10\]\[11\] alu.ALUResult\[11\] _2665_ VGND VGND VPWR VPWR
+ _2667_ sky130_fd_sc_hd__mux2_1
X_5275_ reg_file.memory\[0\]\[10\] VGND VGND VPWR VPWR _2631_ sky130_fd_sc_hd__clkbuf_1
X_4088_ _1720_ _1731_ _1733_ VGND VGND VPWR VPWR _1734_ sky130_fd_sc_hd__mux2_1
X_4157_ _1710_ _1672_ VGND VGND VPWR VPWR _1802_ sky130_fd_sc_hd__nand2_1
X_4226_ _1800_ _1831_ _1870_ _1796_ VGND VGND VPWR VPWR _1871_ sky130_fd_sc_hd__o211a_1
X_3108_ _0764_ _0771_ VGND VGND VPWR VPWR _0773_ sky130_fd_sc_hd__or2_1
XFILLER_0_49_3 VGND VGND VPWR VPWR sky130_fd_sc_hd__fill_2
XTAP_TAPCELL_ROW_38_421 VGND VPWR sky130_fd_sc_hd__tapvpwrvgnd_1
X_3039_ _0701_ _0703_ _0665_ VGND VGND VPWR VPWR _0704_ sky130_fd_sc_hd__mux2_1
XFILLER_0_77_197 VGND VGND VPWR VPWR sky130_fd_sc_hd__decap_8
XFILLER_0_77_186 VGND VGND VPWR VPWR sky130_fd_sc_hd__fill_2
XFILLER_0_77_164 VGND VGND VPWR VPWR sky130_fd_sc_hd__decap_4
XFILLER_0_33_234 VGND VGND VPWR VPWR sky130_fd_sc_hd__fill_1
XTAP_TAPCELL_ROW_44_457 VGND VPWR sky130_fd_sc_hd__tapvpwrvgnd_1
X_3390_ _0538_ _0541_ _0620_ _0622_ VGND VGND VPWR VPWR _1055_ sky130_fd_sc_hd__a31o_4
X_4011_ _1107_ _1656_ VGND VGND VPWR VPWR _1657_ sky130_fd_sc_hd__or2_1
X_5060_ _2517_ VGND VGND VPWR VPWR _0177_ sky130_fd_sc_hd__clkbuf_1
XFILLER_0_90_55 VGND VGND VPWR VPWR sky130_fd_sc_hd__fill_1
X_5962_ clknet_leaf_12_clk _0197_ VGND VGND VPWR VPWR reg_file.memory\[6\]\[24\] sky130_fd_sc_hd__dfxtp_1
XFILLER_0_47_337 VGND VGND VPWR VPWR sky130_fd_sc_hd__fill_1
XFILLER_0_47_326 VGND VGND VPWR VPWR sky130_fd_sc_hd__fill_1
XTAP_TAPCELL_ROW_35_402 VGND VPWR sky130_fd_sc_hd__tapvpwrvgnd_1
X_4913_ alu.ALUResult\[10\] VGND VGND VPWR VPWR _2429_ sky130_fd_sc_hd__buf_1
X_5893_ clknet_leaf_17_clk _0128_ VGND VGND VPWR VPWR reg_file.memory\[4\]\[19\] sky130_fd_sc_hd__dfxtp_1
X_4844_ reg_file.memory\[9\]\[17\] VGND VGND VPWR VPWR _2386_ sky130_fd_sc_hd__clkbuf_1
XFILLER_0_23_60 VGND VGND VPWR VPWR sky130_fd_sc_hd__fill_1
XFILLER_0_70_362 VGND VGND VPWR VPWR sky130_fd_sc_hd__fill_2
X_3657_ _0706_ _1238_ _1240_ VGND VGND VPWR VPWR _1322_ sky130_fd_sc_hd__nand3_1
X_3726_ _1380_ _1378_ _1379_ VGND VGND VPWR VPWR _1382_ sky130_fd_sc_hd__and3_1
X_4775_ _2341_ seven_seg_conv.temp\[12\] VGND VGND VPWR VPWR _2351_ sky130_fd_sc_hd__nand2_1
X_5258_ _2622_ VGND VGND VPWR VPWR _0270_ sky130_fd_sc_hd__clkbuf_1
X_3588_ reg_file.memory\[6\]\[31\] reg_file.memory\[7\]\[31\] _0641_ VGND VGND VPWR
+ VPWR _1253_ sky130_fd_sc_hd__mux2_1
X_5327_ reg_file.memory\[10\]\[3\] alu.ALUResult\[3\] _2654_ VGND VGND VPWR VPWR _2658_
+ sky130_fd_sc_hd__mux2_1
X_4209_ _1679_ _1752_ VGND VGND VPWR VPWR _1854_ sky130_fd_sc_hd__nand2_1
XTAP_TAPCELL_ROW_58_538 VGND VPWR sky130_fd_sc_hd__tapvpwrvgnd_1
X_5189_ reg_file.memory\[8\]\[0\] alu.ALUResult\[0\] _2586_ VGND VGND VPWR VPWR _2587_
+ sky130_fd_sc_hd__mux2_1
XFILLER_0_80_159 VGND VGND VPWR VPWR sky130_fd_sc_hd__decap_8
XFILLER_0_80_137 VGND VGND VPWR VPWR sky130_fd_sc_hd__decap_3
XTAP_TAPCELL_ROW_41_438 VGND VPWR sky130_fd_sc_hd__tapvpwrvgnd_1
XFILLER_0_38_337 VGND VGND VPWR VPWR sky130_fd_sc_hd__fill_1
X_2890_ PC\[1\] VGND VGND VPWR VPWR _0555_ sky130_fd_sc_hd__inv_2
XFILLER_0_56_101 VGND VGND VPWR VPWR sky130_fd_sc_hd__fill_2
XFILLER_0_71_159 VGND VGND VPWR VPWR sky130_fd_sc_hd__fill_2
X_3511_ _1157_ _1175_ VGND VGND VPWR VPWR _1176_ sky130_fd_sc_hd__nand2_1
X_4560_ _2182_ _1314_ _2168_ _2184_ VGND VGND VPWR VPWR _2185_ sky130_fd_sc_hd__o31a_1
X_4491_ _1274_ _1994_ _2112_ _2121_ VGND VGND VPWR VPWR _0511_ sky130_fd_sc_hd__a211o_1
X_5112_ _2544_ VGND VGND VPWR VPWR _0202_ sky130_fd_sc_hd__clkbuf_1
X_6161_ clknet_leaf_11_clk _0396_ VGND VGND VPWR VPWR reg_file.memory\[1\]\[31\] sky130_fd_sc_hd__dfxtp_1
X_3442_ _1055_ _1105_ _1106_ VGND VGND VPWR VPWR _1107_ sky130_fd_sc_hd__o21ai_4
X_6092_ clknet_leaf_13_clk _0327_ VGND VGND VPWR VPWR reg_file.memory\[10\]\[26\]
+ sky130_fd_sc_hd__dfxtp_1
X_3373_ reg_file.memory\[21\]\[7\] _0544_ _0624_ _1037_ VGND VGND VPWR VPWR _1038_
+ sky130_fd_sc_hd__o211ai_2
X_6230_ clknet_leaf_0_clk _0465_ VGND VGND VPWR VPWR reg_file.memory\[2\]\[4\] sky130_fd_sc_hd__dfxtp_1
X_5043_ _2507_ VGND VGND VPWR VPWR _0170_ sky130_fd_sc_hd__clkbuf_1
XFILLER_0_79_215 VGND VGND VPWR VPWR sky130_fd_sc_hd__decap_6
XTAP_TAPCELL_ROW_55_519 VGND VPWR sky130_fd_sc_hd__tapvpwrvgnd_1
X_5876_ clknet_leaf_4_clk _0111_ VGND VGND VPWR VPWR reg_file.memory\[4\]\[2\] sky130_fd_sc_hd__dfxtp_1
XFILLER_0_47_156 VPWR VGND VPWR VGND sky130_ef_sc_hd__decap_12
X_5945_ clknet_leaf_0_clk _0180_ VGND VGND VPWR VPWR reg_file.memory\[6\]\[7\] sky130_fd_sc_hd__dfxtp_1
X_4827_ _2377_ VGND VGND VPWR VPWR _0084_ sky130_fd_sc_hd__clkbuf_1
X_4689_ net2 VGND VGND VPWR VPWR _0027_ sky130_fd_sc_hd__inv_2
X_3709_ alu.ALUResult\[19\] seven_seg_conv.temp\[19\] _1352_ VGND VGND VPWR VPWR _1365_
+ sky130_fd_sc_hd__mux2_1
X_4758_ _1344_ VGND VGND VPWR VPWR _2341_ sky130_fd_sc_hd__buf_4
XFILLER_0_14_18 VGND VGND VPWR VPWR sky130_fd_sc_hd__fill_1
XFILLER_0_53_148 VGND VGND VPWR VPWR sky130_fd_sc_hd__fill_2
XFILLER_0_53_126 VGND VGND VPWR VPWR sky130_fd_sc_hd__fill_2
XFILLER_0_53_104 VGND VGND VPWR VPWR sky130_fd_sc_hd__decap_8
XTAP_TAPCELL_ROW_77_655 VGND VPWR sky130_fd_sc_hd__tapvpwrvgnd_1
X_5730_ seven_seg_conv.digit_counter\[0\] seven_seg_conv.digit_counter\[1\] _2867_
+ net7 _2296_ VGND VGND VPWR VPWR _0497_ sky130_fd_sc_hd__o32a_1
X_2873_ PC\[4\] _0537_ VGND VGND VPWR VPWR _0538_ sky130_fd_sc_hd__nor2_4
X_5661_ _2833_ VGND VGND VPWR VPWR _0462_ sky130_fd_sc_hd__clkbuf_1
XFILLER_0_44_148 VGND VGND VPWR VPWR sky130_fd_sc_hd__fill_2
X_2942_ _0606_ VGND VGND VPWR VPWR _0607_ sky130_fd_sc_hd__clkbuf_4
X_3991_ _0017_ _0018_ VGND VGND VPWR VPWR _1642_ sky130_fd_sc_hd__nor2_1
X_4474_ _1889_ _1987_ _1990_ _1707_ VGND VGND VPWR VPWR _2106_ sky130_fd_sc_hd__o22a_1
X_4612_ _2230_ _2231_ VGND VGND VPWR VPWR _2232_ sky130_fd_sc_hd__nor2_1
X_5592_ _2401_ reg_file.memory\[25\]\[0\] _2797_ VGND VGND VPWR VPWR _2798_ sky130_fd_sc_hd__mux2_1
X_4543_ _0838_ _2164_ _2167_ _1907_ VGND VGND VPWR VPWR _2169_ sky130_fd_sc_hd__o31ai_1
X_6213_ clknet_leaf_15_clk _0448_ VGND VGND VPWR VPWR reg_file.memory\[25\]\[19\]
+ sky130_fd_sc_hd__dfxtp_1
XTAP_TAPCELL_ROW_68_600 VGND VPWR sky130_fd_sc_hd__tapvpwrvgnd_1
X_3356_ reg_file.memory\[15\]\[8\] _0552_ _0616_ _1020_ VGND VGND VPWR VPWR _1021_
+ sky130_fd_sc_hd__a211o_1
X_3425_ reg_file.memory\[15\]\[4\] _0552_ _0615_ VGND VGND VPWR VPWR _1090_ sky130_fd_sc_hd__a21oi_1
X_5026_ _2453_ reg_file.memory\[5\]\[21\] _2497_ VGND VGND VPWR VPWR _2499_ sky130_fd_sc_hd__mux2_1
XFILLER_0_31_3 VGND VGND VPWR VPWR sky130_fd_sc_hd__fill_1
X_3287_ reg_file.memory\[2\]\[12\] _0566_ _0572_ reg_file.memory\[7\]\[12\] _0579_
+ VGND VGND VPWR VPWR _0952_ sky130_fd_sc_hd__o221a_1
X_6144_ clknet_leaf_20_clk _0379_ VGND VGND VPWR VPWR reg_file.memory\[1\]\[14\] sky130_fd_sc_hd__dfxtp_1
X_6075_ clknet_leaf_26_clk _0310_ VGND VGND VPWR VPWR reg_file.memory\[10\]\[9\] sky130_fd_sc_hd__dfxtp_1
XFILLER_0_67_218 VGND VGND VPWR VPWR sky130_fd_sc_hd__decap_6
X_5928_ clknet_leaf_12_clk _0163_ VGND VGND VPWR VPWR reg_file.memory\[5\]\[22\] sky130_fd_sc_hd__dfxtp_1
XTAP_TAPCELL_ROW_0_188 VGND VPWR sky130_fd_sc_hd__tapvpwrvgnd_1
XFILLER_0_35_137 VGND VGND VPWR VPWR sky130_fd_sc_hd__fill_1
X_5859_ clk_div.slow_clk _0001_ VGND VGND VPWR VPWR net12 sky130_fd_sc_hd__dfxtp_1
XTAP_TAPCELL_ROW_74_636 VGND VPWR sky130_fd_sc_hd__tapvpwrvgnd_1
XTAP_TAPCELL_ROW_82_680 VGND VPWR sky130_fd_sc_hd__tapvpwrvgnd_1
XFILLER_0_58_229 VGND VGND VPWR VPWR sky130_fd_sc_hd__decap_6
XFILLER_0_26_159 VGND VGND VPWR VPWR sky130_fd_sc_hd__fill_1
XFILLER_0_1_248 VGND VGND VPWR VPWR sky130_fd_sc_hd__fill_2
X_4190_ _1682_ _1787_ _1786_ VGND VGND VPWR VPWR _1835_ sky130_fd_sc_hd__a21oi_1
XFILLER_0_66_35 VGND VGND VPWR VPWR sky130_fd_sc_hd__decap_8
X_3141_ _0798_ _0805_ VGND VGND VPWR VPWR _0806_ sky130_fd_sc_hd__xnor2_1
X_3210_ _0870_ _0874_ _0611_ VGND VGND VPWR VPWR _0875_ sky130_fd_sc_hd__o21a_1
XFILLER_0_89_354 VGND VGND VPWR VPWR sky130_fd_sc_hd__fill_1
XFILLER_0_89_343 VGND VGND VPWR VPWR sky130_fd_sc_hd__fill_2
XFILLER_0_82_89 VGND VGND VPWR VPWR sky130_fd_sc_hd__fill_2
XFILLER_0_82_56 VGND VGND VPWR VPWR sky130_fd_sc_hd__fill_2
X_3072_ reg_file.memory\[25\]\[26\] _0736_ _0671_ VGND VGND VPWR VPWR _0737_ sky130_fd_sc_hd__mux2_2
X_5644_ _2461_ reg_file.memory\[25\]\[25\] _2819_ VGND VGND VPWR VPWR _2825_ sky130_fd_sc_hd__mux2_1
X_2925_ _0589_ VGND VGND VPWR VPWR _0590_ sky130_fd_sc_hd__clkbuf_4
X_5713_ _2859_ VGND VGND VPWR VPWR _0488_ sky130_fd_sc_hd__clkbuf_1
XFILLER_0_32_129 VGND VGND VPWR VPWR sky130_fd_sc_hd__fill_1
X_3974_ _1628_ _1621_ _1344_ VGND VGND VPWR VPWR _1629_ sky130_fd_sc_hd__a21oi_1
X_5575_ _2461_ reg_file.memory\[21\]\[25\] _2782_ VGND VGND VPWR VPWR _2788_ sky130_fd_sc_hd__mux2_1
X_4457_ _1744_ _2087_ _2088_ _2089_ _2001_ VGND VGND VPWR VPWR _2090_ sky130_fd_sc_hd__o32a_1
X_4526_ _1897_ _2135_ _2153_ VGND VGND VPWR VPWR _2154_ sky130_fd_sc_hd__or3b_1
X_3408_ reg_file.memory\[6\]\[5\] reg_file.memory\[7\]\[5\] _0636_ VGND VGND VPWR
+ VPWR _1073_ sky130_fd_sc_hd__mux2_1
XTAP_TAPCELL_ROW_88_717 VGND VPWR sky130_fd_sc_hd__tapvpwrvgnd_1
X_6127_ clknet_leaf_9_clk _0362_ VGND VGND VPWR VPWR reg_file.memory\[15\]\[29\] sky130_fd_sc_hd__dfxtp_1
X_6058_ clknet_leaf_12_clk _0293_ VGND VGND VPWR VPWR reg_file.memory\[0\]\[24\] sky130_fd_sc_hd__dfxtp_1
X_4388_ _1789_ _1740_ _2021_ _2025_ VGND VGND VPWR VPWR _2026_ sky130_fd_sc_hd__a31o_1
X_3339_ _0999_ _1003_ _0610_ VGND VGND VPWR VPWR _1004_ sky130_fd_sc_hd__o21a_1
X_5009_ _2436_ reg_file.memory\[5\]\[13\] _2486_ VGND VGND VPWR VPWR _2490_ sky130_fd_sc_hd__mux2_1
XTAP_TAPCELL_ROW_71_617 VGND VPWR sky130_fd_sc_hd__tapvpwrvgnd_1
XTAP_TAPCELL_ROW_19_305 VGND VPWR sky130_fd_sc_hd__tapvpwrvgnd_1
XFILLER_0_54_298 VGND VGND VPWR VPWR sky130_fd_sc_hd__fill_1
X_3690_ _1346_ VGND VGND VPWR VPWR _1347_ sky130_fd_sc_hd__buf_4
XFILLER_0_14_107 VGND VGND VPWR VPWR sky130_fd_sc_hd__decap_4
X_4242_ _1754_ _1759_ _1687_ VGND VGND VPWR VPWR _1886_ sky130_fd_sc_hd__mux2_1
X_4311_ _1744_ _1947_ _1951_ _1800_ _1952_ VGND VGND VPWR VPWR _1953_ sky130_fd_sc_hd__o221a_1
X_5360_ reg_file.memory\[10\]\[19\] alu.ALUResult\[19\] _2665_ VGND VGND VPWR VPWR
+ _2675_ sky130_fd_sc_hd__mux2_1
X_5291_ reg_file.memory\[0\]\[18\] VGND VGND VPWR VPWR _2639_ sky130_fd_sc_hd__clkbuf_1
X_3124_ reg_file.memory\[25\]\[23\] _0788_ _0671_ VGND VGND VPWR VPWR _0789_ sky130_fd_sc_hd__mux2_2
X_4173_ _1710_ _1726_ VGND VGND VPWR VPWR _1818_ sky130_fd_sc_hd__nand2_1
X_3055_ _0717_ _0719_ _0665_ VGND VGND VPWR VPWR _0720_ sky130_fd_sc_hd__mux2_1
XFILLER_0_89_195 VPWR VGND VPWR VGND sky130_ef_sc_hd__decap_12
XFILLER_0_89_173 VGND VGND VPWR VPWR sky130_fd_sc_hd__fill_1
XFILLER_0_77_313 VGND VGND VPWR VPWR sky130_fd_sc_hd__fill_2
XFILLER_0_42_70 VGND VGND VPWR VPWR sky130_fd_sc_hd__fill_2
X_3957_ _1604_ _1612_ _1354_ VGND VGND VPWR VPWR _1613_ sky130_fd_sc_hd__a21oi_1
X_5558_ _2444_ reg_file.memory\[21\]\[17\] _2771_ VGND VGND VPWR VPWR _2779_ sky130_fd_sc_hd__mux2_1
X_5627_ _2444_ reg_file.memory\[25\]\[17\] _2808_ VGND VGND VPWR VPWR _2816_ sky130_fd_sc_hd__mux2_1
X_3888_ _1541_ _1543_ _1359_ VGND VGND VPWR VPWR _1544_ sky130_fd_sc_hd__a21o_1
XFILLER_0_5_362 VGND VGND VPWR VPWR sky130_fd_sc_hd__fill_2
X_2908_ _0572_ VGND VGND VPWR VPWR _0573_ sky130_fd_sc_hd__buf_2
X_4509_ _2085_ _2137_ _1733_ VGND VGND VPWR VPWR _2138_ sky130_fd_sc_hd__mux2_1
X_5489_ _2742_ VGND VGND VPWR VPWR _0381_ sky130_fd_sc_hd__clkbuf_1
XFILLER_0_36_276 VGND VGND VPWR VPWR sky130_fd_sc_hd__fill_1
XFILLER_0_36_243 VGND VGND VPWR VPWR sky130_fd_sc_hd__decap_8
XTAP_TAPCELL_ROW_90_734 VGND VPWR sky130_fd_sc_hd__tapvpwrvgnd_1
X_4860_ reg_file.memory\[9\]\[25\] VGND VGND VPWR VPWR _2394_ sky130_fd_sc_hd__clkbuf_1
XFILLER_0_63_47 VGND VGND VPWR VPWR sky130_fd_sc_hd__fill_1
X_3811_ _1466_ _1457_ _1460_ VGND VGND VPWR VPWR _1467_ sky130_fd_sc_hd__mux2_1
X_3673_ _0576_ _0568_ _0631_ _1333_ VGND VGND VPWR VPWR _1334_ sky130_fd_sc_hd__a31o_1
X_5412_ _2703_ VGND VGND VPWR VPWR _0343_ sky130_fd_sc_hd__clkbuf_1
X_3742_ _1383_ _1391_ VGND VGND VPWR VPWR _1398_ sky130_fd_sc_hd__nand2_1
X_4791_ seven_seg_conv.temp\[20\] _1449_ _1635_ VGND VGND VPWR VPWR _2359_ sky130_fd_sc_hd__mux2_1
X_4225_ _1743_ _1846_ _1863_ _1869_ VGND VGND VPWR VPWR _1870_ sky130_fd_sc_hd__or4_1
X_5343_ _2666_ VGND VGND VPWR VPWR _0311_ sky130_fd_sc_hd__clkbuf_1
X_5274_ _2630_ VGND VGND VPWR VPWR _0278_ sky130_fd_sc_hd__clkbuf_1
X_3038_ _0702_ reg_file.memory\[10\]\[28\] _0650_ VGND VGND VPWR VPWR _0703_ sky130_fd_sc_hd__mux2_1
X_4087_ _1732_ VGND VGND VPWR VPWR _1733_ sky130_fd_sc_hd__clkbuf_4
XFILLER_0_77_121 VGND VGND VPWR VPWR sky130_fd_sc_hd__decap_4
X_4156_ _1689_ _1728_ VGND VGND VPWR VPWR _1801_ sky130_fd_sc_hd__nand2_1
X_3107_ _0764_ _0771_ VGND VGND VPWR VPWR _0772_ sky130_fd_sc_hd__nand2_1
XFILLER_0_77_143 VGND VGND VPWR VPWR sky130_fd_sc_hd__fill_2
X_4989_ _2479_ VGND VGND VPWR VPWR _0144_ sky130_fd_sc_hd__clkbuf_1
XFILLER_0_18_287 VGND VGND VPWR VPWR sky130_fd_sc_hd__fill_2
XFILLER_0_33_279 VGND VGND VPWR VPWR sky130_fd_sc_hd__fill_1
XFILLER_0_68_121 VGND VGND VPWR VPWR sky130_fd_sc_hd__decap_4
XFILLER_0_58_69 VGND VGND VPWR VPWR sky130_fd_sc_hd__fill_1
X_5961_ clknet_leaf_10_clk _0196_ VGND VGND VPWR VPWR reg_file.memory\[6\]\[23\] sky130_fd_sc_hd__dfxtp_1
XFILLER_0_74_57 VGND VGND VPWR VPWR sky130_fd_sc_hd__fill_1
X_4010_ alu.ALUControl\[0\] _1655_ VGND VGND VPWR VPWR _1656_ sky130_fd_sc_hd__nand2_2
XFILLER_0_59_110 VGND VGND VPWR VPWR sky130_fd_sc_hd__fill_2
XTAP_TAPCELL_ROW_35_403 VGND VPWR sky130_fd_sc_hd__tapvpwrvgnd_1
XFILLER_0_90_67 VGND VGND VPWR VPWR sky130_fd_sc_hd__decap_8
X_4843_ _2385_ VGND VGND VPWR VPWR _0092_ sky130_fd_sc_hd__clkbuf_1
X_4774_ _2350_ VGND VGND VPWR VPWR _0058_ sky130_fd_sc_hd__clkbuf_1
X_5892_ clknet_leaf_18_clk _0127_ VGND VGND VPWR VPWR reg_file.memory\[4\]\[18\] sky130_fd_sc_hd__dfxtp_1
X_4912_ _2428_ VGND VGND VPWR VPWR _0118_ sky130_fd_sc_hd__clkbuf_1
XFILLER_0_82_190 VGND VGND VPWR VPWR sky130_fd_sc_hd__decap_6
Xclkbuf_leaf_9_clk clknet_1_1__leaf_clk VGND VGND VPWR VPWR clknet_leaf_9_clk sky130_fd_sc_hd__clkbuf_8
X_3656_ _1238_ _1320_ VGND VGND VPWR VPWR _1321_ sky130_fd_sc_hd__nand2_1
X_3587_ reg_file.memory\[21\]\[31\] _0546_ _0626_ _1251_ VGND VGND VPWR VPWR _1252_
+ sky130_fd_sc_hd__o211ai_4
X_3725_ _1378_ _1379_ _1380_ VGND VGND VPWR VPWR _1381_ sky130_fd_sc_hd__a21oi_1
X_4208_ _1849_ _1852_ _1701_ VGND VGND VPWR VPWR _1853_ sky130_fd_sc_hd__mux2_1
X_5257_ reg_file.memory\[0\]\[1\] VGND VGND VPWR VPWR _2622_ sky130_fd_sc_hd__clkbuf_1
XTAP_TAPCELL_ROW_58_539 VGND VPWR sky130_fd_sc_hd__tapvpwrvgnd_1
X_5188_ _2585_ VGND VGND VPWR VPWR _2586_ sky130_fd_sc_hd__clkbuf_4
X_5326_ _2657_ VGND VGND VPWR VPWR _0303_ sky130_fd_sc_hd__clkbuf_1
X_4139_ _1783_ _1784_ VGND VGND VPWR VPWR _1785_ sky130_fd_sc_hd__nor2_1
XFILLER_0_65_113 VGND VGND VPWR VPWR sky130_fd_sc_hd__fill_2
XFILLER_0_38_327 VGND VGND VPWR VPWR sky130_fd_sc_hd__fill_1
XFILLER_0_80_105 VPWR VGND VPWR VGND sky130_ef_sc_hd__decap_12
XTAP_TAPCELL_ROW_41_439 VGND VPWR sky130_fd_sc_hd__tapvpwrvgnd_1
XFILLER_0_56_179 VPWR VGND VPWR VGND sky130_ef_sc_hd__decap_12
XFILLER_0_71_138 VGND VGND VPWR VPWR sky130_fd_sc_hd__fill_1
X_3441_ _0537_ _0547_ _0550_ _0623_ VGND VGND VPWR VPWR _1106_ sky130_fd_sc_hd__or4_1
X_3510_ _1165_ _1174_ VGND VGND VPWR VPWR _1175_ sky130_fd_sc_hd__nand2_1
X_4490_ _1976_ _2113_ _2120_ _2041_ VGND VGND VPWR VPWR _2121_ sky130_fd_sc_hd__o211a_1
XFILLER_0_8_27 VGND VGND VPWR VPWR sky130_fd_sc_hd__fill_1
X_5042_ _2469_ reg_file.memory\[5\]\[29\] _2497_ VGND VGND VPWR VPWR _2507_ sky130_fd_sc_hd__mux2_1
X_5111_ _2469_ reg_file.memory\[6\]\[29\] _2534_ VGND VGND VPWR VPWR _2544_ sky130_fd_sc_hd__mux2_1
X_6160_ clknet_leaf_11_clk _0395_ VGND VGND VPWR VPWR reg_file.memory\[1\]\[30\] sky130_fd_sc_hd__dfxtp_1
X_6091_ clknet_leaf_11_clk _0326_ VGND VGND VPWR VPWR reg_file.memory\[10\]\[25\]
+ sky130_fd_sc_hd__dfxtp_1
X_3372_ reg_file.memory\[15\]\[7\] _0552_ _0616_ _1036_ VGND VGND VPWR VPWR _1037_
+ sky130_fd_sc_hd__a211o_1
XFILLER_0_47_113 VPWR VGND VPWR VGND sky130_ef_sc_hd__decap_12
X_5944_ clknet_leaf_0_clk _0179_ VGND VGND VPWR VPWR reg_file.memory\[6\]\[6\] sky130_fd_sc_hd__dfxtp_1
X_5875_ clknet_leaf_4_clk _0110_ VGND VGND VPWR VPWR reg_file.memory\[4\]\[1\] sky130_fd_sc_hd__dfxtp_1
XFILLER_0_62_116 VPWR VGND VPWR VGND sky130_ef_sc_hd__decap_12
XFILLER_0_50_81 VGND VGND VPWR VPWR sky130_fd_sc_hd__decap_3
X_4826_ reg_file.memory\[9\]\[8\] VGND VGND VPWR VPWR _2377_ sky130_fd_sc_hd__clkbuf_1
X_4757_ _1344_ VGND VGND VPWR VPWR _2340_ sky130_fd_sc_hd__buf_4
X_4688_ net2 VGND VGND VPWR VPWR _0026_ sky130_fd_sc_hd__inv_2
X_5309_ reg_file.memory\[0\]\[27\] VGND VGND VPWR VPWR _2648_ sky130_fd_sc_hd__clkbuf_1
X_3639_ _0901_ _1213_ _1215_ VGND VGND VPWR VPWR _1304_ sky130_fd_sc_hd__and3_1
X_3708_ _1363_ VGND VGND VPWR VPWR _1364_ sky130_fd_sc_hd__inv_2
XPHY_EDGE_ROW_49_Left_140 VGND VGND VPWR VPWR sky130_fd_sc_hd__decap_3
XFILLER_0_34_363 VGND VGND VPWR VPWR sky130_fd_sc_hd__fill_1
XFILLER_0_30_29 VGND VGND VPWR VPWR sky130_fd_sc_hd__fill_1
X_3990_ _0017_ _0018_ VGND VGND VPWR VPWR _1641_ sky130_fd_sc_hd__nor2b_1
X_2872_ PC\[3\] VGND VGND VPWR VPWR _0537_ sky130_fd_sc_hd__buf_2
X_5660_ reg_file.memory\[2\]\[1\] VGND VGND VPWR VPWR _2833_ sky130_fd_sc_hd__clkbuf_1
X_4611_ _1231_ _2229_ _1902_ VGND VGND VPWR VPWR _2231_ sky130_fd_sc_hd__a21o_1
X_2941_ _0605_ VGND VGND VPWR VPWR _0606_ sky130_fd_sc_hd__clkbuf_4
X_5591_ _2796_ VGND VGND VPWR VPWR _2797_ sky130_fd_sc_hd__buf_4
XFILLER_0_29_113 VGND VGND VPWR VPWR sky130_fd_sc_hd__fill_2
X_4473_ _2104_ VGND VGND VPWR VPWR _2105_ sky130_fd_sc_hd__inv_2
X_4542_ _2164_ _2167_ _0838_ VGND VGND VPWR VPWR _2168_ sky130_fd_sc_hd__o21a_1
X_3424_ _1084_ _1088_ _0610_ VGND VGND VPWR VPWR _1089_ sky130_fd_sc_hd__o21ai_1
X_6212_ clknet_leaf_15_clk _0447_ VGND VGND VPWR VPWR reg_file.memory\[25\]\[18\]
+ sky130_fd_sc_hd__dfxtp_1
XFILLER_0_25_363 VGND VGND VPWR VPWR sky130_fd_sc_hd__fill_1
XFILLER_0_4_235 VGND VGND VPWR VPWR sky130_fd_sc_hd__decap_3
XTAP_TAPCELL_ROW_68_601 VGND VPWR sky130_fd_sc_hd__tapvpwrvgnd_1
X_3286_ _0943_ _0950_ VGND VGND VPWR VPWR _0951_ sky130_fd_sc_hd__nand2_1
X_5025_ _2498_ VGND VGND VPWR VPWR _0161_ sky130_fd_sc_hd__clkbuf_1
X_3355_ _1015_ _1019_ _0610_ VGND VGND VPWR VPWR _1020_ sky130_fd_sc_hd__o21a_1
XFILLER_0_29_71 VGND VGND VPWR VPWR sky130_fd_sc_hd__decap_6
X_6143_ clknet_leaf_20_clk _0378_ VGND VGND VPWR VPWR reg_file.memory\[1\]\[13\] sky130_fd_sc_hd__dfxtp_1
X_6074_ clknet_leaf_26_clk _0309_ VGND VGND VPWR VPWR reg_file.memory\[10\]\[8\] sky130_fd_sc_hd__dfxtp_1
XFILLER_0_24_3 VGND VGND VPWR VPWR sky130_fd_sc_hd__fill_2
X_5927_ clknet_leaf_16_clk _0162_ VGND VGND VPWR VPWR reg_file.memory\[5\]\[21\] sky130_fd_sc_hd__dfxtp_1
XTAP_TAPCELL_ROW_0_189 VGND VPWR sky130_fd_sc_hd__tapvpwrvgnd_1
XFILLER_0_0_83 VGND VGND VPWR VPWR sky130_fd_sc_hd__fill_1
XFILLER_0_90_211 VGND VGND VPWR VPWR sky130_fd_sc_hd__decap_6
X_4809_ _2367_ _1347_ _2368_ seven_seg_conv.temp\[28\] _2341_ VGND VGND VPWR VPWR
+ _0075_ sky130_fd_sc_hd__a32o_1
XFILLER_0_31_311 VGND VGND VPWR VPWR sky130_fd_sc_hd__fill_2
X_5789_ clk_div.slow_clk _0072_ VGND VGND VPWR VPWR seven_seg_conv.temp\[25\] sky130_fd_sc_hd__dfxtp_1
X_5858_ clk_div.slow_clk _0000_ VGND VGND VPWR VPWR net11 sky130_fd_sc_hd__dfxtp_1
XFILLER_0_16_330 VGND VGND VPWR VPWR sky130_fd_sc_hd__decap_8
XFILLER_0_16_363 VGND VGND VPWR VPWR sky130_fd_sc_hd__fill_1
XPHY_EDGE_ROW_17_Right_17 VGND VGND VPWR VPWR sky130_fd_sc_hd__decap_3
XPHY_EDGE_ROW_26_Right_26 VGND VGND VPWR VPWR sky130_fd_sc_hd__decap_3
XTAP_TAPCELL_ROW_74_637 VGND VPWR sky130_fd_sc_hd__tapvpwrvgnd_1
XTAP_TAPCELL_ROW_82_681 VGND VPWR sky130_fd_sc_hd__tapvpwrvgnd_1
XPHY_EDGE_ROW_35_Right_35 VGND VGND VPWR VPWR sky130_fd_sc_hd__decap_3
XFILLER_0_41_108 VGND VGND VPWR VPWR sky130_fd_sc_hd__decap_4
XFILLER_0_66_69 VGND VGND VPWR VPWR sky130_fd_sc_hd__decap_3
X_3071_ _0733_ _0735_ _0665_ VGND VGND VPWR VPWR _0736_ sky130_fd_sc_hd__mux2_1
X_3140_ reg_file.memory\[25\]\[22\] _0804_ _0670_ VGND VGND VPWR VPWR _0805_ sky130_fd_sc_hd__mux2_2
XPHY_EDGE_ROW_44_Right_44 VGND VGND VPWR VPWR sky130_fd_sc_hd__decap_3
X_5712_ reg_file.memory\[2\]\[27\] VGND VGND VPWR VPWR _2859_ sky130_fd_sc_hd__clkbuf_1
XPHY_EDGE_ROW_53_Right_53 VGND VGND VPWR VPWR sky130_fd_sc_hd__decap_3
X_3973_ _1353_ _1626_ VGND VGND VPWR VPWR _1628_ sky130_fd_sc_hd__nor2_1
XFILLER_0_72_200 VGND VGND VPWR VPWR sky130_fd_sc_hd__fill_2
X_2924_ _0588_ VGND VGND VPWR VPWR _0589_ sky130_fd_sc_hd__clkbuf_4
X_5574_ _2787_ VGND VGND VPWR VPWR _0421_ sky130_fd_sc_hd__clkbuf_1
X_4525_ _2060_ _2050_ _2152_ _1940_ VGND VGND VPWR VPWR _2153_ sky130_fd_sc_hd__o22a_1
X_5643_ _2824_ VGND VGND VPWR VPWR _0453_ sky130_fd_sc_hd__clkbuf_1
XFILLER_0_17_127 VGND VGND VPWR VPWR sky130_fd_sc_hd__fill_2
XTAP_TAPCELL_ROW_88_718 VGND VPWR sky130_fd_sc_hd__tapvpwrvgnd_1
X_4456_ _1738_ _1845_ _1828_ VGND VGND VPWR VPWR _2089_ sky130_fd_sc_hd__and3_1
X_6126_ clknet_leaf_9_clk _0361_ VGND VGND VPWR VPWR reg_file.memory\[15\]\[28\] sky130_fd_sc_hd__dfxtp_1
XPHY_EDGE_ROW_62_Right_62 VGND VGND VPWR VPWR sky130_fd_sc_hd__decap_3
X_4387_ _1940_ _2024_ VGND VGND VPWR VPWR _2025_ sky130_fd_sc_hd__nor2_1
XFILLER_0_40_163 VGND VGND VPWR VPWR sky130_fd_sc_hd__decap_8
XFILLER_0_40_141 VGND VGND VPWR VPWR sky130_fd_sc_hd__decap_6
X_3407_ reg_file.memory\[21\]\[5\] _0543_ _1070_ _1071_ _0624_ VGND VGND VPWR VPWR
+ _1072_ sky130_fd_sc_hd__o221a_2
X_3338_ _0572_ _1000_ _1002_ _0605_ VGND VGND VPWR VPWR _1003_ sky130_fd_sc_hd__o211a_1
X_6057_ clknet_leaf_10_clk _0292_ VGND VGND VPWR VPWR reg_file.memory\[0\]\[23\] sky130_fd_sc_hd__dfxtp_1
X_3269_ reg_file.memory\[25\]\[14\] _0933_ _0669_ VGND VGND VPWR VPWR _0934_ sky130_fd_sc_hd__mux2_2
X_5008_ _2489_ VGND VGND VPWR VPWR _0153_ sky130_fd_sc_hd__clkbuf_1
XPHY_EDGE_ROW_71_Right_71 VGND VGND VPWR VPWR sky130_fd_sc_hd__decap_3
XTAP_TAPCELL_ROW_71_618 VGND VPWR sky130_fd_sc_hd__tapvpwrvgnd_1
XPHY_EDGE_ROW_80_Right_80 VGND VGND VPWR VPWR sky130_fd_sc_hd__decap_3
XFILLER_0_16_160 VGND VGND VPWR VPWR sky130_fd_sc_hd__fill_1
XFILLER_0_86_347 VGND VGND VPWR VPWR sky130_fd_sc_hd__fill_1
XTAP_TAPCELL_ROW_27_350 VGND VPWR sky130_fd_sc_hd__tapvpwrvgnd_1
XTAP_TAPCELL_ROW_19_306 VGND VPWR sky130_fd_sc_hd__tapvpwrvgnd_1
XTAP_TAPCELL_ROW_10_250 VGND VPWR sky130_fd_sc_hd__tapvpwrvgnd_1
X_4241_ _1700_ _1749_ _1687_ VGND VGND VPWR VPWR _1885_ sky130_fd_sc_hd__mux2_1
X_4310_ _1796_ VGND VGND VPWR VPWR _1952_ sky130_fd_sc_hd__buf_2
X_5290_ _2638_ VGND VGND VPWR VPWR _0286_ sky130_fd_sc_hd__clkbuf_1
X_3054_ _0718_ reg_file.memory\[10\]\[27\] _0650_ VGND VGND VPWR VPWR _0719_ sky130_fd_sc_hd__mux2_1
X_3123_ _0785_ _0787_ _0665_ VGND VGND VPWR VPWR _0788_ sky130_fd_sc_hd__mux2_1
X_4172_ _1689_ _1723_ VGND VGND VPWR VPWR _1817_ sky130_fd_sc_hd__nand2_1
XTAP_TAPCELL_ROW_33_386 VGND VPWR sky130_fd_sc_hd__tapvpwrvgnd_1
X_2907_ _0571_ VGND VGND VPWR VPWR _0572_ sky130_fd_sc_hd__buf_2
X_3956_ _1354_ _1611_ _1609_ _1608_ VGND VGND VPWR VPWR _1612_ sky130_fd_sc_hd__a2bb2o_1
X_4508_ _2114_ _2136_ _1719_ VGND VGND VPWR VPWR _2137_ sky130_fd_sc_hd__mux2_1
X_5557_ _2778_ VGND VGND VPWR VPWR _0413_ sky130_fd_sc_hd__clkbuf_1
X_5626_ _2815_ VGND VGND VPWR VPWR _0445_ sky130_fd_sc_hd__clkbuf_1
X_3887_ _1538_ _1539_ _1542_ _1359_ VGND VGND VPWR VPWR _1543_ sky130_fd_sc_hd__o22ai_2
X_5488_ reg_file.memory\[1\]\[16\] VGND VGND VPWR VPWR _2742_ sky130_fd_sc_hd__clkbuf_1
XFILLER_0_13_185 VGND VGND VPWR VPWR sky130_fd_sc_hd__decap_8
X_4439_ _2048_ _2072_ _1819_ VGND VGND VPWR VPWR _2073_ sky130_fd_sc_hd__mux2_1
X_6109_ clknet_leaf_2_clk _0344_ VGND VGND VPWR VPWR reg_file.memory\[15\]\[11\] sky130_fd_sc_hd__dfxtp_1
XFILLER_0_6_82 VGND VGND VPWR VPWR sky130_fd_sc_hd__fill_2
XFILLER_0_51_225 VGND VGND VPWR VPWR sky130_fd_sc_hd__decap_4
XTAP_TAPCELL_ROW_90_735 VGND VPWR sky130_fd_sc_hd__tapvpwrvgnd_1
XFILLER_0_86_188 VGND VGND VPWR VPWR sky130_fd_sc_hd__decap_8
XFILLER_0_59_347 VGND VGND VPWR VPWR sky130_fd_sc_hd__fill_1
X_3741_ _1393_ _1394_ _1395_ _1396_ VGND VGND VPWR VPWR _1397_ sky130_fd_sc_hd__a2bb2o_1
XFILLER_0_27_222 VGND VGND VPWR VPWR sky130_fd_sc_hd__fill_2
X_3810_ _1457_ _1464_ VGND VGND VPWR VPWR _1466_ sky130_fd_sc_hd__nand2_1
X_4790_ _2358_ VGND VGND VPWR VPWR _0066_ sky130_fd_sc_hd__clkbuf_1
X_3672_ _0537_ _0542_ _0643_ _1332_ VGND VGND VPWR VPWR _1333_ sky130_fd_sc_hd__o31a_1
XFILLER_0_42_247 VGND VGND VPWR VPWR sky130_fd_sc_hd__fill_2
XFILLER_0_42_236 VGND VGND VPWR VPWR sky130_fd_sc_hd__decap_4
X_5411_ _2429_ reg_file.memory\[15\]\[10\] _2702_ VGND VGND VPWR VPWR _2703_ sky130_fd_sc_hd__mux2_1
XFILLER_0_12_85 VGND VGND VPWR VPWR sky130_fd_sc_hd__decap_6
X_5342_ reg_file.memory\[10\]\[10\] alu.ALUResult\[10\] _2665_ VGND VGND VPWR VPWR
+ _2666_ sky130_fd_sc_hd__mux2_1
X_4224_ _1742_ _1868_ VGND VGND VPWR VPWR _1869_ sky130_fd_sc_hd__and2_1
X_4155_ _1091_ VGND VGND VPWR VPWR _1800_ sky130_fd_sc_hd__buf_2
X_5273_ reg_file.memory\[0\]\[9\] VGND VGND VPWR VPWR _2630_ sky130_fd_sc_hd__clkbuf_1
X_3037_ reg_file.memory\[8\]\[28\] reg_file.memory\[9\]\[28\] _0641_ VGND VGND VPWR
+ VPWR _0702_ sky130_fd_sc_hd__mux2_1
XFILLER_0_77_155 VGND VGND VPWR VPWR sky130_fd_sc_hd__fill_2
XFILLER_0_65_306 VGND VGND VPWR VPWR sky130_fd_sc_hd__fill_2
X_4086_ _1703_ VGND VGND VPWR VPWR _1732_ sky130_fd_sc_hd__clkbuf_4
X_3106_ reg_file.memory\[25\]\[24\] _0770_ _0670_ VGND VGND VPWR VPWR _0771_ sky130_fd_sc_hd__mux2_1
XFILLER_0_53_92 VPWR VGND VPWR VGND sky130_ef_sc_hd__decap_12
X_4988_ _2415_ reg_file.memory\[5\]\[3\] _2475_ VGND VGND VPWR VPWR _2479_ sky130_fd_sc_hd__mux2_1
X_3939_ _1355_ _1594_ _1589_ VGND VGND VPWR VPWR _1595_ sky130_fd_sc_hd__o21bai_1
XPHY_EDGE_ROW_12_Left_103 VGND VGND VPWR VPWR sky130_fd_sc_hd__decap_3
X_5609_ _2806_ VGND VGND VPWR VPWR _0437_ sky130_fd_sc_hd__clkbuf_1
XFILLER_0_33_247 VGND VGND VPWR VPWR sky130_fd_sc_hd__fill_1
XPHY_EDGE_ROW_21_Left_112 VGND VGND VPWR VPWR sky130_fd_sc_hd__decap_3
XFILLER_0_83_147 VGND VGND VPWR VPWR sky130_fd_sc_hd__decap_4
XFILLER_0_83_125 VGND VGND VPWR VPWR sky130_fd_sc_hd__decap_6
XFILLER_0_68_155 VGND VGND VPWR VPWR sky130_fd_sc_hd__decap_3
XPHY_EDGE_ROW_30_Left_121 VGND VGND VPWR VPWR sky130_fd_sc_hd__decap_3
XFILLER_0_83_169 VPWR VGND VPWR VGND sky130_ef_sc_hd__decap_12
XFILLER_0_71_309 VGND VGND VPWR VPWR sky130_fd_sc_hd__fill_2
X_5960_ clknet_leaf_16_clk _0195_ VGND VGND VPWR VPWR reg_file.memory\[6\]\[22\] sky130_fd_sc_hd__dfxtp_1
X_4911_ _2427_ reg_file.memory\[4\]\[9\] _2409_ VGND VGND VPWR VPWR _2428_ sky130_fd_sc_hd__mux2_1
X_5891_ clknet_leaf_19_clk _0126_ VGND VGND VPWR VPWR reg_file.memory\[4\]\[17\] sky130_fd_sc_hd__dfxtp_1
X_3724_ seven_seg_conv.temp\[28\] alu.ALUResult\[28\] _1345_ VGND VGND VPWR VPWR _1380_
+ sky130_fd_sc_hd__mux2_1
X_4773_ seven_seg_conv.temp\[11\] _2349_ _2334_ VGND VGND VPWR VPWR _2350_ sky130_fd_sc_hd__mux2_1
X_4842_ reg_file.memory\[9\]\[16\] VGND VGND VPWR VPWR _2385_ sky130_fd_sc_hd__clkbuf_1
XFILLER_0_15_203 VGND VGND VPWR VPWR sky130_fd_sc_hd__decap_4
XFILLER_0_15_225 VGND VGND VPWR VPWR sky130_fd_sc_hd__fill_1
X_3655_ _1235_ _1237_ VGND VGND VPWR VPWR _1320_ sky130_fd_sc_hd__or2_1
X_3586_ reg_file.memory\[15\]\[31\] _0554_ _0618_ _1250_ VGND VGND VPWR VPWR _1251_
+ sky130_fd_sc_hd__a211o_1
X_5325_ reg_file.memory\[10\]\[2\] alu.ALUResult\[2\] _2654_ VGND VGND VPWR VPWR _2657_
+ sky130_fd_sc_hd__mux2_1
X_4138_ _1119_ _1165_ _1697_ VGND VGND VPWR VPWR _1784_ sky130_fd_sc_hd__and3_1
X_5187_ _2405_ _2584_ VGND VGND VPWR VPWR _2585_ sky130_fd_sc_hd__nor2_4
X_4207_ _1850_ _1851_ VGND VGND VPWR VPWR _1852_ sky130_fd_sc_hd__nand2_1
XFILLER_0_54_3 VGND VGND VPWR VPWR sky130_fd_sc_hd__decap_4
X_5256_ _2621_ VGND VGND VPWR VPWR _0269_ sky130_fd_sc_hd__clkbuf_1
X_4069_ _1659_ _1714_ VGND VGND VPWR VPWR _1715_ sky130_fd_sc_hd__nand2_1
XTAP_TAPCELL_ROW_66_584 VGND VPWR sky130_fd_sc_hd__tapvpwrvgnd_1
XFILLER_0_80_117 VGND VGND VPWR VPWR sky130_fd_sc_hd__decap_4
XFILLER_0_65_169 VGND VGND VPWR VPWR sky130_fd_sc_hd__decap_6
XFILLER_0_60_38 VGND VGND VPWR VPWR sky130_fd_sc_hd__fill_2
XFILLER_0_56_169 VGND VGND VPWR VPWR sky130_fd_sc_hd__fill_1
XFILLER_0_44_309 VGND VGND VPWR VPWR sky130_fd_sc_hd__fill_2
XFILLER_0_29_317 VGND VGND VPWR VPWR sky130_fd_sc_hd__fill_1
XFILLER_0_69_69 VGND VGND VPWR VPWR sky130_fd_sc_hd__decap_8
X_3440_ reg_file.memory\[21\]\[3\] _0615_ _1104_ VGND VGND VPWR VPWR _1105_ sky130_fd_sc_hd__a21oi_2
X_3371_ _1031_ _1035_ _0610_ VGND VGND VPWR VPWR _1036_ sky130_fd_sc_hd__o21a_1
X_5041_ _2506_ VGND VGND VPWR VPWR _0169_ sky130_fd_sc_hd__clkbuf_1
X_5110_ _2543_ VGND VGND VPWR VPWR _0201_ sky130_fd_sc_hd__clkbuf_1
X_6090_ clknet_leaf_12_clk _0325_ VGND VGND VPWR VPWR reg_file.memory\[10\]\[24\]
+ sky130_fd_sc_hd__dfxtp_1
X_5874_ clknet_leaf_4_clk _0109_ VGND VGND VPWR VPWR reg_file.memory\[4\]\[0\] sky130_fd_sc_hd__dfxtp_1
XFILLER_0_47_125 VPWR VGND VPWR VGND sky130_ef_sc_hd__decap_12
X_5943_ clknet_leaf_0_clk _0178_ VGND VGND VPWR VPWR reg_file.memory\[6\]\[5\] sky130_fd_sc_hd__dfxtp_1
X_4687_ net2 VGND VGND VPWR VPWR _0025_ sky130_fd_sc_hd__inv_2
XFILLER_0_62_128 VPWR VGND VPWR VGND sky130_ef_sc_hd__decap_12
XFILLER_0_47_169 VPWR VGND VPWR VGND sky130_ef_sc_hd__decap_12
X_3707_ alu.ALUResult\[17\] seven_seg_conv.temp\[17\] _1352_ VGND VGND VPWR VPWR _1363_
+ sky130_fd_sc_hd__mux2_1
X_4756_ _2339_ VGND VGND VPWR VPWR _0051_ sky130_fd_sc_hd__clkbuf_1
X_4825_ _2376_ VGND VGND VPWR VPWR _0083_ sky130_fd_sc_hd__clkbuf_1
X_3569_ _0738_ _1232_ _1233_ VGND VGND VPWR VPWR _1234_ sky130_fd_sc_hd__a21oi_1
X_5308_ _2647_ VGND VGND VPWR VPWR _0295_ sky130_fd_sc_hd__clkbuf_1
X_3638_ _1272_ _1274_ _1275_ _1302_ VGND VGND VPWR VPWR _1303_ sky130_fd_sc_hd__or4_1
X_5239_ reg_file.memory\[8\]\[24\] alu.ALUResult\[24\] _2608_ VGND VGND VPWR VPWR
+ _2613_ sky130_fd_sc_hd__mux2_1
XFILLER_0_53_139 VGND VGND VPWR VPWR sky130_fd_sc_hd__fill_2
XFILLER_0_61_183 VGND VGND VPWR VPWR sky130_fd_sc_hd__decap_6
XFILLER_0_46_191 VGND VGND VPWR VPWR sky130_fd_sc_hd__decap_4
XFILLER_0_34_342 VGND VGND VPWR VPWR sky130_fd_sc_hd__fill_2
X_2940_ _0604_ VGND VGND VPWR VPWR _0605_ sky130_fd_sc_hd__clkbuf_4
XFILLER_0_84_253 VGND VGND VPWR VPWR sky130_fd_sc_hd__decap_3
XFILLER_0_84_242 VGND VGND VPWR VPWR sky130_fd_sc_hd__fill_1
X_5590_ _1342_ _2795_ VGND VGND VPWR VPWR _2796_ sky130_fd_sc_hd__nand2_4
X_2871_ alu.ALUControl\[0\] _0014_ VGND VGND VPWR VPWR _0012_ sky130_fd_sc_hd__nand2_1
X_4610_ _1231_ _2229_ VGND VGND VPWR VPWR _2230_ sky130_fd_sc_hd__nor2_1
X_4541_ _0846_ _0853_ VGND VGND VPWR VPWR _2167_ sky130_fd_sc_hd__and2b_1
XFILLER_0_29_169 VGND VGND VPWR VPWR sky130_fd_sc_hd__fill_1
XFILLER_0_4_258 VGND VGND VPWR VPWR sky130_fd_sc_hd__fill_2
X_4472_ _1985_ _2020_ _2103_ _1924_ VGND VGND VPWR VPWR _2104_ sky130_fd_sc_hd__o22a_1
X_3423_ _0571_ _1085_ _1087_ _0605_ VGND VGND VPWR VPWR _1088_ sky130_fd_sc_hd__o211a_1
X_6211_ clknet_leaf_15_clk _0446_ VGND VGND VPWR VPWR reg_file.memory\[25\]\[17\]
+ sky130_fd_sc_hd__dfxtp_1
X_6142_ clknet_leaf_24_clk _0377_ VGND VGND VPWR VPWR reg_file.memory\[1\]\[12\] sky130_fd_sc_hd__dfxtp_1
X_3354_ _0571_ _1016_ _1018_ _0605_ VGND VGND VPWR VPWR _1019_ sky130_fd_sc_hd__o211a_1
XFILLER_0_20_63 VGND VGND VPWR VPWR sky130_fd_sc_hd__fill_2
XFILLER_0_20_85 VGND VGND VPWR VPWR sky130_fd_sc_hd__fill_2
X_5024_ _2450_ reg_file.memory\[5\]\[20\] _2497_ VGND VGND VPWR VPWR _2498_ sky130_fd_sc_hd__mux2_1
X_3285_ reg_file.memory\[25\]\[13\] _0949_ _0669_ VGND VGND VPWR VPWR _0950_ sky130_fd_sc_hd__mux2_2
XFILLER_0_17_3 VGND VGND VPWR VPWR sky130_fd_sc_hd__fill_1
X_6073_ clknet_leaf_26_clk _0308_ VGND VGND VPWR VPWR reg_file.memory\[10\]\[7\] sky130_fd_sc_hd__dfxtp_1
X_5857_ clknet_leaf_11_clk _0107_ VGND VGND VPWR VPWR reg_file.memory\[9\]\[31\] sky130_fd_sc_hd__dfxtp_1
X_5926_ clknet_leaf_17_clk _0161_ VGND VGND VPWR VPWR reg_file.memory\[5\]\[20\] sky130_fd_sc_hd__dfxtp_1
X_4739_ _2328_ _2329_ VGND VGND VPWR VPWR _0044_ sky130_fd_sc_hd__nor2_1
XFILLER_0_50_109 VPWR VGND VPWR VGND sky130_ef_sc_hd__decap_12
X_4808_ _1376_ alu.ALUResult\[29\] VGND VGND VPWR VPWR _2368_ sky130_fd_sc_hd__or2_1
X_5788_ clk_div.slow_clk _0071_ VGND VGND VPWR VPWR seven_seg_conv.temp\[24\] sky130_fd_sc_hd__dfxtp_1
XFILLER_0_25_19 VGND VGND VPWR VPWR sky130_fd_sc_hd__fill_1
XTAP_TAPCELL_ROW_82_682 VGND VPWR sky130_fd_sc_hd__tapvpwrvgnd_1
XFILLER_0_81_223 VGND VGND VPWR VPWR sky130_fd_sc_hd__fill_1
XFILLER_0_81_201 VGND VGND VPWR VPWR sky130_fd_sc_hd__decap_3
XFILLER_0_34_194 VGND VGND VPWR VPWR sky130_fd_sc_hd__fill_2
X_3070_ _0734_ reg_file.memory\[10\]\[26\] _0650_ VGND VGND VPWR VPWR _0735_ sky130_fd_sc_hd__mux2_1
X_2923_ _0560_ _0538_ _0563_ _0587_ VGND VGND VPWR VPWR _0588_ sky130_fd_sc_hd__a31o_1
X_5711_ _2858_ VGND VGND VPWR VPWR _0487_ sky130_fd_sc_hd__clkbuf_1
X_3972_ _1625_ _1621_ _1626_ VGND VGND VPWR VPWR _1627_ sky130_fd_sc_hd__a21bo_1
XFILLER_0_15_63 VGND VGND VPWR VPWR sky130_fd_sc_hd__decap_6
X_4524_ _2102_ _2151_ _1704_ VGND VGND VPWR VPWR _2152_ sky130_fd_sc_hd__mux2_1
X_5573_ _2459_ reg_file.memory\[21\]\[24\] _2782_ VGND VGND VPWR VPWR _2787_ sky130_fd_sc_hd__mux2_1
X_5642_ _2459_ reg_file.memory\[25\]\[24\] _2819_ VGND VGND VPWR VPWR _2824_ sky130_fd_sc_hd__mux2_1
XFILLER_0_31_73 VGND VGND VPWR VPWR sky130_fd_sc_hd__fill_1
XFILLER_0_25_194 VGND VGND VPWR VPWR sky130_fd_sc_hd__fill_1
XTAP_TAPCELL_ROW_13_270 VGND VPWR sky130_fd_sc_hd__tapvpwrvgnd_1
XTAP_TAPCELL_ROW_88_719 VGND VPWR sky130_fd_sc_hd__tapvpwrvgnd_1
X_4455_ _1658_ _1966_ _1974_ _1950_ VGND VGND VPWR VPWR _2088_ sky130_fd_sc_hd__a2bb2o_1
XPHY_EDGE_ROW_68_Left_159 VGND VGND VPWR VPWR sky130_fd_sc_hd__decap_3
X_4386_ _1942_ _2023_ _1732_ VGND VGND VPWR VPWR _2024_ sky130_fd_sc_hd__mux2_1
X_6125_ clknet_leaf_13_clk _0360_ VGND VGND VPWR VPWR reg_file.memory\[15\]\[27\]
+ sky130_fd_sc_hd__dfxtp_1
X_3406_ reg_file.memory\[15\]\[5\] _0552_ _0616_ VGND VGND VPWR VPWR _1071_ sky130_fd_sc_hd__a21o_1
X_3337_ _0598_ _1001_ VGND VGND VPWR VPWR _1002_ sky130_fd_sc_hd__or2_1
XPHY_EDGE_ROW_77_Left_168 VGND VGND VPWR VPWR sky130_fd_sc_hd__decap_3
XTAP_TAPCELL_ROW_71_619 VGND VPWR sky130_fd_sc_hd__tapvpwrvgnd_1
X_6056_ clknet_leaf_12_clk _0291_ VGND VGND VPWR VPWR reg_file.memory\[0\]\[22\] sky130_fd_sc_hd__dfxtp_1
X_3199_ reg_file.memory\[5\]\[18\] _0863_ _0648_ VGND VGND VPWR VPWR _0864_ sky130_fd_sc_hd__mux2_1
X_3268_ _0930_ _0932_ _0664_ VGND VGND VPWR VPWR _0933_ sky130_fd_sc_hd__mux2_1
X_5007_ _2434_ reg_file.memory\[5\]\[12\] _2486_ VGND VGND VPWR VPWR _2489_ sky130_fd_sc_hd__mux2_1
XFILLER_0_63_223 VGND VGND VPWR VPWR sky130_fd_sc_hd__fill_1
X_5909_ clknet_leaf_1_clk _0144_ VGND VGND VPWR VPWR reg_file.memory\[5\]\[3\] sky130_fd_sc_hd__dfxtp_1
XPHY_EDGE_ROW_86_Left_177 VGND VGND VPWR VPWR sky130_fd_sc_hd__decap_3
XFILLER_0_6_3 VPWR VGND VPWR VGND sky130_ef_sc_hd__decap_12
XFILLER_0_36_29 VGND VGND VPWR VPWR sky130_fd_sc_hd__fill_2
XTAP_TAPCELL_ROW_19_307 VGND VPWR sky130_fd_sc_hd__tapvpwrvgnd_1
XTAP_TAPCELL_ROW_27_351 VGND VPWR sky130_fd_sc_hd__tapvpwrvgnd_1
XFILLER_0_6_309 VGND VGND VPWR VPWR sky130_fd_sc_hd__decap_8
XTAP_TAPCELL_ROW_10_251 VGND VPWR sky130_fd_sc_hd__tapvpwrvgnd_1
X_4240_ _1882_ _1883_ _1737_ VGND VGND VPWR VPWR _1884_ sky130_fd_sc_hd__mux2_1
X_4171_ _1767_ VGND VGND VPWR VPWR _1816_ sky130_fd_sc_hd__clkbuf_4
X_3122_ _0786_ reg_file.memory\[10\]\[23\] _0649_ VGND VGND VPWR VPWR _0787_ sky130_fd_sc_hd__mux2_1
X_3053_ reg_file.memory\[8\]\[27\] reg_file.memory\[9\]\[27\] _0641_ VGND VGND VPWR
+ VPWR _0718_ sky130_fd_sc_hd__mux2_1
X_2906_ _0570_ VGND VGND VPWR VPWR _0571_ sky130_fd_sc_hd__buf_2
XTAP_TAPCELL_ROW_33_387 VGND VPWR sky130_fd_sc_hd__tapvpwrvgnd_1
X_5625_ _2442_ reg_file.memory\[25\]\[16\] _2808_ VGND VGND VPWR VPWR _2815_ sky130_fd_sc_hd__mux2_1
X_3886_ _1525_ _1537_ VGND VGND VPWR VPWR _1542_ sky130_fd_sc_hd__xnor2_1
X_3955_ _1605_ _1606_ VGND VGND VPWR VPWR _1611_ sky130_fd_sc_hd__xnor2_1
XFILLER_0_5_331 VGND VGND VPWR VPWR sky130_fd_sc_hd__decap_4
X_4507_ _1812_ _1847_ VGND VGND VPWR VPWR _2136_ sky130_fd_sc_hd__nand2_1
X_4438_ _1753_ _1758_ VGND VGND VPWR VPWR _2072_ sky130_fd_sc_hd__nand2_1
X_5556_ _2442_ reg_file.memory\[21\]\[16\] _2771_ VGND VGND VPWR VPWR _2778_ sky130_fd_sc_hd__mux2_1
X_5487_ _2741_ VGND VGND VPWR VPWR _0380_ sky130_fd_sc_hd__clkbuf_1
XFILLER_0_67_80 VPWR VGND VPWR VGND sky130_ef_sc_hd__decap_12
X_4369_ _1940_ _2007_ VGND VGND VPWR VPWR _2008_ sky130_fd_sc_hd__nor2_1
X_6108_ clknet_leaf_23_clk _0343_ VGND VGND VPWR VPWR reg_file.memory\[15\]\[10\]
+ sky130_fd_sc_hd__dfxtp_1
X_6039_ clknet_leaf_0_clk _0274_ VGND VGND VPWR VPWR reg_file.memory\[0\]\[5\] sky130_fd_sc_hd__dfxtp_1
XFILLER_0_83_318 VGND VGND VPWR VPWR sky130_fd_sc_hd__fill_1
XTAP_TAPCELL_ROW_24_332 VGND VPWR sky130_fd_sc_hd__tapvpwrvgnd_1
XFILLER_0_86_101 VPWR VGND VPWR VGND sky130_ef_sc_hd__decap_12
XFILLER_0_59_337 VGND VGND VPWR VPWR sky130_fd_sc_hd__fill_1
XTAP_TAPCELL_ROW_90_736 VGND VPWR sky130_fd_sc_hd__tapvpwrvgnd_1
XFILLER_0_74_307 VGND VGND VPWR VPWR sky130_fd_sc_hd__fill_1
X_3740_ _1383_ _1391_ VGND VGND VPWR VPWR _1396_ sky130_fd_sc_hd__or2b_1
X_3671_ _0537_ _0541_ _0576_ VGND VGND VPWR VPWR _1332_ sky130_fd_sc_hd__a21oi_1
X_5410_ _2690_ VGND VGND VPWR VPWR _2702_ sky130_fd_sc_hd__clkbuf_4
XTAP_TAPCELL_ROW_30_368 VGND VPWR sky130_fd_sc_hd__tapvpwrvgnd_1
X_5341_ _2653_ VGND VGND VPWR VPWR _2665_ sky130_fd_sc_hd__clkbuf_4
X_4085_ _1725_ _1730_ _1719_ VGND VGND VPWR VPWR _1731_ sky130_fd_sc_hd__mux2_1
X_3105_ _0767_ _0769_ _0665_ VGND VGND VPWR VPWR _0770_ sky130_fd_sc_hd__mux2_1
X_4223_ _1767_ _1867_ VGND VGND VPWR VPWR _1868_ sky130_fd_sc_hd__nor2_1
X_4154_ _1736_ _1793_ _1797_ _1799_ VGND VGND VPWR VPWR _0505_ sky130_fd_sc_hd__a31o_1
X_5272_ _2629_ VGND VGND VPWR VPWR _0277_ sky130_fd_sc_hd__clkbuf_1
X_3036_ reg_file.memory\[0\]\[28\] _0700_ _0656_ VGND VGND VPWR VPWR _0701_ sky130_fd_sc_hd__mux2_1
XFILLER_0_53_60 VGND VGND VPWR VPWR sky130_fd_sc_hd__fill_2
XFILLER_0_73_362 VGND VGND VPWR VPWR sky130_fd_sc_hd__fill_2
X_4987_ _2478_ VGND VGND VPWR VPWR _0143_ sky130_fd_sc_hd__clkbuf_1
X_5608_ _2425_ reg_file.memory\[25\]\[8\] _2797_ VGND VGND VPWR VPWR _2806_ sky130_fd_sc_hd__mux2_1
X_3869_ alu.ALUResult\[11\] seven_seg_conv.temp\[11\] _1352_ VGND VGND VPWR VPWR _1525_
+ sky130_fd_sc_hd__mux2_1
X_3938_ _1586_ _1593_ VGND VGND VPWR VPWR _1594_ sky130_fd_sc_hd__xnor2_1
X_5539_ _2425_ reg_file.memory\[21\]\[8\] _2760_ VGND VGND VPWR VPWR _2769_ sky130_fd_sc_hd__mux2_1
XFILLER_0_68_145 VGND VGND VPWR VPWR sky130_fd_sc_hd__fill_1
XFILLER_0_64_362 VGND VGND VPWR VPWR sky130_fd_sc_hd__fill_2
XFILLER_0_56_318 VGND VGND VPWR VPWR sky130_fd_sc_hd__fill_2
XFILLER_0_58_38 VGND VGND VPWR VPWR sky130_fd_sc_hd__fill_2
XFILLER_0_90_47 VGND VGND VPWR VPWR sky130_fd_sc_hd__decap_8
XFILLER_0_59_167 VGND VGND VPWR VPWR sky130_fd_sc_hd__fill_1
XFILLER_0_59_134 VGND VGND VPWR VPWR sky130_fd_sc_hd__fill_1
XFILLER_0_59_101 VGND VGND VPWR VPWR sky130_fd_sc_hd__decap_3
X_4910_ alu.ALUResult\[9\] VGND VGND VPWR VPWR _2427_ sky130_fd_sc_hd__buf_1
X_4841_ _2384_ VGND VGND VPWR VPWR _0091_ sky130_fd_sc_hd__clkbuf_1
X_5890_ clknet_leaf_19_clk _0125_ VGND VGND VPWR VPWR reg_file.memory\[4\]\[16\] sky130_fd_sc_hd__dfxtp_1
X_3654_ _1234_ _1318_ VGND VGND VPWR VPWR _1319_ sky130_fd_sc_hd__or2_1
X_3723_ alu.ALUResult\[30\] _1351_ alu.ALUResult\[29\] alu.ALUResult\[31\] VGND VGND
+ VPWR VPWR _1379_ sky130_fd_sc_hd__or4b_1
X_4772_ _1520_ _1522_ VGND VGND VPWR VPWR _2349_ sky130_fd_sc_hd__nand2_1
X_3585_ _1245_ _1249_ _0612_ VGND VGND VPWR VPWR _1250_ sky130_fd_sc_hd__o21a_1
X_5255_ reg_file.memory\[0\]\[0\] VGND VGND VPWR VPWR _2621_ sky130_fd_sc_hd__clkbuf_1
XFILLER_0_2_120 VGND VGND VPWR VPWR sky130_fd_sc_hd__fill_1
X_5324_ _2656_ VGND VGND VPWR VPWR _0302_ sky130_fd_sc_hd__clkbuf_1
X_4068_ _0689_ _1697_ VGND VGND VPWR VPWR _1714_ sky130_fd_sc_hd__nand2_1
X_5186_ _1330_ _1342_ _2583_ VGND VGND VPWR VPWR _2584_ sky130_fd_sc_hd__or3_2
X_4137_ _1165_ _1782_ VGND VGND VPWR VPWR _1783_ sky130_fd_sc_hd__nor2_1
X_4206_ _1675_ _1750_ VGND VGND VPWR VPWR _1851_ sky130_fd_sc_hd__nand2_1
XFILLER_0_48_93 VPWR VGND VPWR VGND sky130_ef_sc_hd__decap_12
X_3019_ reg_file.memory\[5\]\[29\] _0683_ _0650_ VGND VGND VPWR VPWR _0684_ sky130_fd_sc_hd__mux2_1
XTAP_TAPCELL_ROW_66_585 VGND VPWR sky130_fd_sc_hd__tapvpwrvgnd_1
XFILLER_0_73_192 VGND VGND VPWR VPWR sky130_fd_sc_hd__decap_4
XFILLER_0_73_181 VGND VGND VPWR VPWR sky130_fd_sc_hd__decap_8
XFILLER_0_46_362 VGND VGND VPWR VPWR sky130_fd_sc_hd__fill_2
XFILLER_0_21_229 VGND VGND VPWR VPWR sky130_fd_sc_hd__fill_1
XTAP_TAPCELL_ROW_57_530 VGND VPWR sky130_fd_sc_hd__tapvpwrvgnd_1
XFILLER_0_44_29 VGND VGND VPWR VPWR sky130_fd_sc_hd__fill_1
XTAP_TAPCELL_ROW_40_430 VGND VPWR sky130_fd_sc_hd__tapvpwrvgnd_1
X_3370_ _0571_ _1032_ _1034_ _0605_ VGND VGND VPWR VPWR _1035_ sky130_fd_sc_hd__o211a_1
X_5040_ _2467_ reg_file.memory\[5\]\[28\] _2497_ VGND VGND VPWR VPWR _2506_ sky130_fd_sc_hd__mux2_1
X_5873_ clk_div.slow_clk _0023_ VGND VGND VPWR VPWR seven_seg_conv.digit_counter\[3\]
+ sky130_fd_sc_hd__dfxtp_1
XTAP_TAPCELL_ROW_63_566 VGND VPWR sky130_fd_sc_hd__tapvpwrvgnd_1
XFILLER_0_47_137 VGND VGND VPWR VPWR sky130_fd_sc_hd__decap_4
XFILLER_0_47_104 VGND VGND VPWR VPWR sky130_fd_sc_hd__decap_8
X_5942_ clknet_leaf_1_clk _0177_ VGND VGND VPWR VPWR reg_file.memory\[6\]\[4\] sky130_fd_sc_hd__dfxtp_1
X_4824_ reg_file.memory\[9\]\[7\] VGND VGND VPWR VPWR _2376_ sky130_fd_sc_hd__clkbuf_1
X_4686_ net2 VGND VGND VPWR VPWR _0024_ sky130_fd_sc_hd__inv_2
XFILLER_0_70_195 VGND VGND VPWR VPWR sky130_fd_sc_hd__fill_1
XFILLER_0_55_181 VGND VGND VPWR VPWR sky130_fd_sc_hd__fill_2
X_3637_ _1278_ _1280_ _1282_ _1301_ VGND VGND VPWR VPWR _1302_ sky130_fd_sc_hd__nand4_1
X_3706_ alu.ALUResult\[15\] seven_seg_conv.temp\[15\] _1352_ VGND VGND VPWR VPWR _1362_
+ sky130_fd_sc_hd__mux2_1
XFILLER_0_7_245 VGND VGND VPWR VPWR sky130_fd_sc_hd__fill_2
X_4755_ seven_seg_conv.temp\[4\] _1593_ _2334_ VGND VGND VPWR VPWR _2339_ sky130_fd_sc_hd__mux2_1
X_5238_ _2612_ VGND VGND VPWR VPWR _0260_ sky130_fd_sc_hd__clkbuf_1
X_3568_ _0714_ _0721_ VGND VGND VPWR VPWR _1233_ sky130_fd_sc_hd__xnor2_1
X_3499_ reg_file.memory\[21\]\[0\] _0615_ _1055_ _1163_ VGND VGND VPWR VPWR _1164_
+ sky130_fd_sc_hd__a211o_1
X_5307_ reg_file.memory\[0\]\[26\] VGND VGND VPWR VPWR _2647_ sky130_fd_sc_hd__clkbuf_1
XFILLER_0_78_262 VGND VGND VPWR VPWR sky130_fd_sc_hd__fill_2
X_5169_ _2459_ reg_file.memory\[7\]\[24\] _2570_ VGND VGND VPWR VPWR _2575_ sky130_fd_sc_hd__mux2_1
XFILLER_0_19_340 VGND VGND VPWR VPWR sky130_fd_sc_hd__fill_2
X_2870_ alu.ALUControl\[1\] alu.ALUControl\[2\] VGND VGND VPWR VPWR _0014_ sky130_fd_sc_hd__nor2_8
Xclkbuf_leaf_10_clk clknet_1_1__leaf_clk VGND VGND VPWR VPWR clknet_leaf_10_clk sky130_fd_sc_hd__clkbuf_8
X_4471_ _2049_ _2102_ _1732_ VGND VGND VPWR VPWR _2103_ sky130_fd_sc_hd__mux2_1
XFILLER_0_52_195 VGND VGND VPWR VPWR sky130_fd_sc_hd__fill_1
XFILLER_0_52_184 VGND VGND VPWR VPWR sky130_fd_sc_hd__decap_3
X_4540_ _1797_ _2160_ _2161_ _2166_ VGND VGND VPWR VPWR _0515_ sky130_fd_sc_hd__a211o_1
XFILLER_0_20_42 VGND VGND VPWR VPWR sky130_fd_sc_hd__fill_2
X_3422_ _0597_ _1086_ VGND VGND VPWR VPWR _1087_ sky130_fd_sc_hd__or2_1
X_6210_ clknet_leaf_22_clk _0445_ VGND VGND VPWR VPWR reg_file.memory\[25\]\[16\]
+ sky130_fd_sc_hd__dfxtp_1
X_3353_ _0598_ _1017_ VGND VGND VPWR VPWR _1018_ sky130_fd_sc_hd__or2_1
X_3284_ _0946_ _0948_ _0664_ VGND VGND VPWR VPWR _0949_ sky130_fd_sc_hd__mux2_1
X_6072_ clknet_leaf_26_clk _0307_ VGND VGND VPWR VPWR reg_file.memory\[10\]\[6\] sky130_fd_sc_hd__dfxtp_1
X_6141_ clknet_leaf_24_clk _0376_ VGND VGND VPWR VPWR reg_file.memory\[1\]\[11\] sky130_fd_sc_hd__dfxtp_1
X_5023_ _2474_ VGND VGND VPWR VPWR _2497_ sky130_fd_sc_hd__buf_4
X_5856_ clknet_leaf_11_clk _0106_ VGND VGND VPWR VPWR reg_file.memory\[9\]\[30\] sky130_fd_sc_hd__dfxtp_1
XFILLER_0_61_93 VGND VGND VPWR VPWR sky130_fd_sc_hd__fill_1
X_4807_ alu.ALUResult\[31\] VGND VGND VPWR VPWR _2367_ sky130_fd_sc_hd__dlymetal6s2s_1
XFILLER_0_28_170 VGND VGND VPWR VPWR sky130_fd_sc_hd__decap_6
X_5787_ clk_div.slow_clk _0070_ VGND VGND VPWR VPWR seven_seg_conv.temp\[23\] sky130_fd_sc_hd__dfxtp_1
X_5925_ clknet_leaf_19_clk _0160_ VGND VGND VPWR VPWR reg_file.memory\[5\]\[19\] sky130_fd_sc_hd__dfxtp_1
XPHY_EDGE_ROW_3_Right_3 VGND VGND VPWR VPWR sky130_fd_sc_hd__decap_3
XFILLER_0_0_63 VGND VGND VPWR VPWR sky130_fd_sc_hd__fill_1
XFILLER_0_0_85 VGND VGND VPWR VPWR sky130_fd_sc_hd__decap_4
X_2999_ _0663_ VGND VGND VPWR VPWR _0664_ sky130_fd_sc_hd__clkbuf_4
X_4738_ clk_div.counter\[14\] _2325_ clk_div.counter\[15\] VGND VGND VPWR VPWR _2329_
+ sky130_fd_sc_hd__a21oi_1
X_4669_ _1779_ _2264_ VGND VGND VPWR VPWR _2284_ sky130_fd_sc_hd__nor2_1
XTAP_TAPCELL_ROW_8_236 VGND VPWR sky130_fd_sc_hd__tapvpwrvgnd_1
Xclkbuf_1_1__f_clk clknet_0_clk VGND VGND VPWR VPWR clknet_1_1__leaf_clk sky130_fd_sc_hd__clkbuf_16
XTAP_TAPCELL_ROW_82_683 VGND VPWR sky130_fd_sc_hd__tapvpwrvgnd_1
XFILLER_0_41_19 VGND VGND VPWR VPWR sky130_fd_sc_hd__decap_3
XFILLER_0_34_173 VGND VGND VPWR VPWR sky130_fd_sc_hd__fill_2
XFILLER_0_66_49 VGND VGND VPWR VPWR sky130_fd_sc_hd__decap_4
XFILLER_0_82_37 VGND VGND VPWR VPWR sky130_fd_sc_hd__fill_1
X_5641_ _2823_ VGND VGND VPWR VPWR _0452_ sky130_fd_sc_hd__clkbuf_1
X_2922_ _0583_ _0584_ _0586_ VGND VGND VPWR VPWR _0587_ sky130_fd_sc_hd__o21ai_1
XFILLER_0_72_224 VGND VGND VPWR VPWR sky130_fd_sc_hd__fill_2
X_5710_ reg_file.memory\[2\]\[26\] VGND VGND VPWR VPWR _2858_ sky130_fd_sc_hd__clkbuf_1
X_3971_ _1354_ _1604_ _1610_ _1613_ VGND VGND VPWR VPWR _1626_ sky130_fd_sc_hd__a31o_1
X_5572_ _2786_ VGND VGND VPWR VPWR _0420_ sky130_fd_sc_hd__clkbuf_1
X_4523_ _2126_ _2150_ _1719_ VGND VGND VPWR VPWR _2151_ sky130_fd_sc_hd__mux2_1
X_4454_ _1970_ _2060_ _2086_ _2064_ VGND VGND VPWR VPWR _2087_ sky130_fd_sc_hd__o22ai_1
XFILLER_0_40_154 VGND VGND VPWR VPWR sky130_fd_sc_hd__fill_2
XFILLER_0_40_110 VGND VGND VPWR VPWR sky130_fd_sc_hd__fill_2
XTAP_TAPCELL_ROW_13_271 VGND VPWR sky130_fd_sc_hd__tapvpwrvgnd_1
X_4385_ _1983_ _2022_ _1701_ VGND VGND VPWR VPWR _2023_ sky130_fd_sc_hd__mux2_1
XFILLER_0_56_93 VGND VGND VPWR VPWR sky130_fd_sc_hd__decap_8
X_6124_ clknet_leaf_15_clk _0359_ VGND VGND VPWR VPWR reg_file.memory\[15\]\[26\]
+ sky130_fd_sc_hd__dfxtp_1
X_6055_ clknet_leaf_16_clk _0290_ VGND VGND VPWR VPWR reg_file.memory\[0\]\[21\] sky130_fd_sc_hd__dfxtp_1
X_3405_ _1065_ _1069_ _0610_ VGND VGND VPWR VPWR _1070_ sky130_fd_sc_hd__o21a_1
XFILLER_0_0_284 VPWR VGND VPWR VGND sky130_ef_sc_hd__decap_12
X_3267_ _0931_ reg_file.memory\[10\]\[14\] _0647_ VGND VGND VPWR VPWR _0932_ sky130_fd_sc_hd__mux2_1
X_5006_ _2488_ VGND VGND VPWR VPWR _0152_ sky130_fd_sc_hd__clkbuf_1
X_3336_ reg_file.memory\[0\]\[9\] reg_file.memory\[1\]\[9\] _0591_ VGND VGND VPWR
+ VPWR _1001_ sky130_fd_sc_hd__mux2_1
X_3198_ reg_file.memory\[6\]\[18\] reg_file.memory\[7\]\[18\] _0639_ VGND VGND VPWR
+ VPWR _0863_ sky130_fd_sc_hd__mux2_1
XFILLER_0_63_279 VGND VGND VPWR VPWR sky130_fd_sc_hd__fill_1
X_5908_ clknet_leaf_4_clk _0143_ VGND VGND VPWR VPWR reg_file.memory\[5\]\[2\] sky130_fd_sc_hd__dfxtp_1
X_5839_ clknet_leaf_20_clk _0089_ VGND VGND VPWR VPWR reg_file.memory\[9\]\[13\] sky130_fd_sc_hd__dfxtp_1
XTAP_TAPCELL_ROW_27_352 VGND VPWR sky130_fd_sc_hd__tapvpwrvgnd_1
XTAP_TAPCELL_ROW_10_252 VGND VPWR sky130_fd_sc_hd__tapvpwrvgnd_1
X_3121_ reg_file.memory\[8\]\[23\] reg_file.memory\[9\]\[23\] _0640_ VGND VGND VPWR
+ VPWR _0786_ sky130_fd_sc_hd__mux2_1
X_4170_ _1807_ _1814_ _1704_ VGND VGND VPWR VPWR _1815_ sky130_fd_sc_hd__mux2_1
X_3052_ reg_file.memory\[0\]\[27\] _0716_ _0656_ VGND VGND VPWR VPWR _0717_ sky130_fd_sc_hd__mux2_1
XFILLER_0_26_85 VGND VGND VPWR VPWR sky130_fd_sc_hd__fill_1
X_2905_ _0569_ _0565_ VGND VGND VPWR VPWR _0570_ sky130_fd_sc_hd__nand2_2
XFILLER_0_45_213 VGND VGND VPWR VPWR sky130_fd_sc_hd__decap_4
XFILLER_0_42_51 VGND VGND VPWR VPWR sky130_fd_sc_hd__decap_6
XFILLER_0_42_40 VGND VGND VPWR VPWR sky130_fd_sc_hd__fill_2
XTAP_TAPCELL_ROW_33_388 VGND VPWR sky130_fd_sc_hd__tapvpwrvgnd_1
X_5624_ _2814_ VGND VGND VPWR VPWR _0444_ sky130_fd_sc_hd__clkbuf_1
X_3885_ _1536_ VGND VGND VPWR VPWR _1541_ sky130_fd_sc_hd__clkinvlp_2
X_3954_ _1608_ _1609_ VGND VGND VPWR VPWR _1610_ sky130_fd_sc_hd__and2_1
XFILLER_0_9_126 VGND VGND VPWR VPWR sky130_fd_sc_hd__fill_1
X_4437_ _2060_ VGND VGND VPWR VPWR _2071_ sky130_fd_sc_hd__buf_2
X_4506_ _2129_ VGND VGND VPWR VPWR _2135_ sky130_fd_sc_hd__buf_2
X_5555_ _2777_ VGND VGND VPWR VPWR _0412_ sky130_fd_sc_hd__clkbuf_1
X_5486_ reg_file.memory\[1\]\[15\] VGND VGND VPWR VPWR _2741_ sky130_fd_sc_hd__clkbuf_1
X_4299_ _1775_ _1784_ VGND VGND VPWR VPWR _1941_ sky130_fd_sc_hd__nor2_1
XFILLER_0_67_92 VGND VGND VPWR VPWR sky130_fd_sc_hd__decap_3
XFILLER_0_67_70 VGND VGND VPWR VPWR sky130_fd_sc_hd__fill_2
X_4368_ _1926_ _2006_ _1703_ VGND VGND VPWR VPWR _2007_ sky130_fd_sc_hd__mux2_1
X_6107_ clknet_leaf_2_clk _0342_ VGND VGND VPWR VPWR reg_file.memory\[15\]\[9\] sky130_fd_sc_hd__dfxtp_1
X_6038_ clknet_leaf_0_clk _0273_ VGND VGND VPWR VPWR reg_file.memory\[0\]\[4\] sky130_fd_sc_hd__dfxtp_1
X_3319_ reg_file.memory\[4\]\[10\] reg_file.memory\[5\]\[10\] _0591_ VGND VGND VPWR
+ VPWR _0984_ sky130_fd_sc_hd__mux2_1
XFILLER_0_83_91 VGND VGND VPWR VPWR sky130_fd_sc_hd__fill_2
XTAP_TAPCELL_ROW_24_333 VGND VPWR sky130_fd_sc_hd__tapvpwrvgnd_1
XTAP_TAPCELL_ROW_90_737 VGND VPWR sky130_fd_sc_hd__tapvpwrvgnd_1
X_3670_ _0549_ ctrl_unit.PCWrite VGND VGND VPWR VPWR _0007_ sky130_fd_sc_hd__nor2_1
XTAP_TAPCELL_ROW_30_369 VGND VPWR sky130_fd_sc_hd__tapvpwrvgnd_1
XFILLER_0_12_32 VGND VGND VPWR VPWR sky130_fd_sc_hd__fill_2
X_4222_ _1786_ _1866_ VGND VGND VPWR VPWR _1867_ sky130_fd_sc_hd__or2_1
XFILLER_0_10_157 VGND VGND VPWR VPWR sky130_fd_sc_hd__fill_2
XFILLER_0_10_168 VGND VGND VPWR VPWR sky130_fd_sc_hd__fill_1
X_5340_ _2664_ VGND VGND VPWR VPWR _0310_ sky130_fd_sc_hd__clkbuf_1
X_5271_ reg_file.memory\[0\]\[8\] VGND VGND VPWR VPWR _2629_ sky130_fd_sc_hd__clkbuf_1
X_3035_ reg_file.memory\[5\]\[28\] _0699_ _0650_ VGND VGND VPWR VPWR _0700_ sky130_fd_sc_hd__mux2_1
X_4084_ _1727_ _1729_ VGND VGND VPWR VPWR _1730_ sky130_fd_sc_hd__nand2_1
X_4153_ _1175_ _1798_ _1655_ VGND VGND VPWR VPWR _1799_ sky130_fd_sc_hd__a21oi_1
X_3104_ _0768_ reg_file.memory\[10\]\[24\] _0649_ VGND VGND VPWR VPWR _0769_ sky130_fd_sc_hd__mux2_1
XFILLER_0_77_113 VGND VGND VPWR VPWR sky130_fd_sc_hd__decap_4
X_4986_ _2413_ reg_file.memory\[5\]\[2\] _2475_ VGND VGND VPWR VPWR _2478_ sky130_fd_sc_hd__mux2_1
X_3937_ _1590_ _1582_ _1579_ VGND VGND VPWR VPWR _1593_ sky130_fd_sc_hd__a21o_1
XFILLER_0_85_190 VPWR VGND VPWR VGND sky130_ef_sc_hd__decap_12
XFILLER_0_33_205 VGND VGND VPWR VPWR sky130_fd_sc_hd__fill_2
X_5538_ _2768_ VGND VGND VPWR VPWR _0404_ sky130_fd_sc_hd__clkbuf_1
X_5607_ _2805_ VGND VGND VPWR VPWR _0436_ sky130_fd_sc_hd__clkbuf_1
X_3868_ _1516_ _1520_ _1522_ VGND VGND VPWR VPWR _1524_ sky130_fd_sc_hd__and3_1
X_3799_ _1453_ _1454_ _1450_ _1451_ VGND VGND VPWR VPWR _1455_ sky130_fd_sc_hd__a211o_1
XTAP_TAPCELL_ROW_21_314 VGND VPWR sky130_fd_sc_hd__tapvpwrvgnd_1
X_5469_ _2732_ VGND VGND VPWR VPWR _0371_ sky130_fd_sc_hd__clkbuf_1
XFILLER_0_24_216 VGND VGND VPWR VPWR sky130_fd_sc_hd__decap_3
XFILLER_0_90_26 VGND VGND VPWR VPWR sky130_fd_sc_hd__fill_2
XFILLER_0_74_138 VGND VGND VPWR VPWR sky130_fd_sc_hd__fill_2
XFILLER_0_59_113 VGND VGND VPWR VPWR sky130_fd_sc_hd__decap_3
XTAP_TAPCELL_ROW_43_450 VGND VPWR sky130_fd_sc_hd__tapvpwrvgnd_1
X_4840_ reg_file.memory\[9\]\[15\] VGND VGND VPWR VPWR _2384_ sky130_fd_sc_hd__clkbuf_1
X_3653_ _1233_ _0738_ _1232_ VGND VGND VPWR VPWR _1318_ sky130_fd_sc_hd__and3_1
X_3722_ alu.ALUResult\[28\] _1375_ _1345_ _1376_ _1377_ VGND VGND VPWR VPWR _1378_
+ sky130_fd_sc_hd__o2111ai_2
X_4771_ _2340_ _1537_ _2348_ VGND VGND VPWR VPWR _0057_ sky130_fd_sc_hd__o21ai_1
X_5185_ ctrl_unit.RegWrite _1328_ VGND VGND VPWR VPWR _2583_ sky130_fd_sc_hd__nand2_1
X_5254_ _2620_ VGND VGND VPWR VPWR _0268_ sky130_fd_sc_hd__clkbuf_1
X_4205_ _1679_ _1747_ VGND VGND VPWR VPWR _1850_ sky130_fd_sc_hd__nand2_1
X_3584_ _0575_ _1246_ _1248_ _0607_ VGND VGND VPWR VPWR _1249_ sky130_fd_sc_hd__o211a_1
XFILLER_0_48_83 VGND VGND VPWR VPWR sky130_fd_sc_hd__fill_1
X_5323_ reg_file.memory\[10\]\[1\] alu.ALUResult\[1\] _2654_ VGND VGND VPWR VPWR _2656_
+ sky130_fd_sc_hd__mux2_1
X_3018_ reg_file.memory\[6\]\[29\] reg_file.memory\[7\]\[29\] _0641_ VGND VGND VPWR
+ VPWR _0683_ sky130_fd_sc_hd__mux2_1
X_4067_ _1689_ _1709_ _1712_ VGND VGND VPWR VPWR _1713_ sky130_fd_sc_hd__a21bo_1
XTAP_TAPCELL_ROW_66_586 VGND VPWR sky130_fd_sc_hd__tapvpwrvgnd_1
X_4136_ _1137_ _1669_ VGND VGND VPWR VPWR _1782_ sky130_fd_sc_hd__or2b_1
X_4969_ alu.ALUResult\[28\] VGND VGND VPWR VPWR _2467_ sky130_fd_sc_hd__dlymetal6s2s_1
XFILLER_0_21_208 VGND VGND VPWR VPWR sky130_fd_sc_hd__decap_3
XTAP_TAPCELL_ROW_57_531 VGND VPWR sky130_fd_sc_hd__tapvpwrvgnd_1
XFILLER_0_56_138 VGND VGND VPWR VPWR sky130_fd_sc_hd__fill_2
XFILLER_0_71_119 VGND VGND VPWR VPWR sky130_fd_sc_hd__fill_1
XFILLER_0_69_27 VGND VGND VPWR VPWR sky130_fd_sc_hd__fill_1
XFILLER_0_64_182 VGND VGND VPWR VPWR sky130_fd_sc_hd__fill_1
XTAP_TAPCELL_ROW_40_431 VGND VPWR sky130_fd_sc_hd__tapvpwrvgnd_1
XPHY_EDGE_ROW_0_Left_91 VGND VGND VPWR VPWR sky130_fd_sc_hd__decap_3
XFILLER_0_20_296 VGND VGND VPWR VPWR sky130_fd_sc_hd__decap_3
X_5941_ clknet_leaf_1_clk _0176_ VGND VGND VPWR VPWR reg_file.memory\[6\]\[3\] sky130_fd_sc_hd__dfxtp_1
X_5872_ clk_div.slow_clk _0022_ VGND VGND VPWR VPWR seven_seg_conv.digit_counter\[2\]
+ sky130_fd_sc_hd__dfxtp_1
XTAP_TAPCELL_ROW_63_567 VGND VPWR sky130_fd_sc_hd__tapvpwrvgnd_1
XFILLER_0_34_85 VGND VGND VPWR VPWR sky130_fd_sc_hd__fill_2
XFILLER_0_28_363 VGND VGND VPWR VPWR sky130_fd_sc_hd__fill_1
X_4754_ _2338_ VGND VGND VPWR VPWR _0050_ sky130_fd_sc_hd__clkbuf_1
X_4823_ _2375_ VGND VGND VPWR VPWR _0082_ sky130_fd_sc_hd__clkbuf_1
X_4685_ _2296_ _2294_ VGND VGND VPWR VPWR _0023_ sky130_fd_sc_hd__xnor2_1
XFILLER_0_59_60 VPWR VGND VPWR VGND sky130_ef_sc_hd__decap_12
X_3567_ _1229_ _1230_ _1231_ VGND VGND VPWR VPWR _1232_ sky130_fd_sc_hd__o21ai_1
X_3636_ _1284_ _1300_ VGND VGND VPWR VPWR _1301_ sky130_fd_sc_hd__nor2_1
X_3705_ seven_seg_conv.temp\[13\] alu.ALUResult\[13\] _1347_ VGND VGND VPWR VPWR _1361_
+ sky130_fd_sc_hd__mux2_1
XFILLER_0_7_279 VGND VGND VPWR VPWR sky130_fd_sc_hd__fill_1
X_5306_ _2646_ VGND VGND VPWR VPWR _0294_ sky130_fd_sc_hd__clkbuf_1
X_5168_ _2574_ VGND VGND VPWR VPWR _0228_ sky130_fd_sc_hd__clkbuf_1
X_5237_ reg_file.memory\[8\]\[23\] alu.ALUResult\[23\] _2608_ VGND VGND VPWR VPWR
+ _2612_ sky130_fd_sc_hd__mux2_1
X_3498_ reg_file.memory\[15\]\[0\] _0609_ _0543_ _1162_ VGND VGND VPWR VPWR _1163_
+ sky130_fd_sc_hd__o211a_1
X_5099_ _2457_ reg_file.memory\[6\]\[23\] _2534_ VGND VGND VPWR VPWR _2538_ sky130_fd_sc_hd__mux2_1
X_4119_ _1759_ _1764_ _1687_ VGND VGND VPWR VPWR _1765_ sky130_fd_sc_hd__mux2_1
XTAP_TAPCELL_ROW_54_512 VGND VPWR sky130_fd_sc_hd__tapvpwrvgnd_1
XFILLER_0_38_138 VGND VGND VPWR VPWR sky130_fd_sc_hd__fill_2
XFILLER_0_84_200 VPWR VGND VPWR VGND sky130_ef_sc_hd__decap_12
XFILLER_0_71_39 VGND VGND VPWR VPWR sky130_fd_sc_hd__fill_1
XTAP_TAPCELL_ROW_60_548 VGND VPWR sky130_fd_sc_hd__tapvpwrvgnd_1
X_4470_ _2072_ _2101_ _1686_ VGND VGND VPWR VPWR _2102_ sky130_fd_sc_hd__mux2_1
XFILLER_0_52_152 VPWR VGND VPWR VGND sky130_ef_sc_hd__decap_12
XFILLER_0_52_141 VGND VGND VPWR VPWR sky130_fd_sc_hd__fill_2
X_3421_ reg_file.memory\[0\]\[4\] reg_file.memory\[1\]\[4\] _0589_ VGND VGND VPWR
+ VPWR _1086_ sky130_fd_sc_hd__mux2_1
XFILLER_0_4_227 VGND VGND VPWR VPWR sky130_fd_sc_hd__decap_8
XFILLER_0_20_32 VGND VGND VPWR VPWR sky130_fd_sc_hd__fill_1
X_6140_ clknet_leaf_24_clk _0375_ VGND VGND VPWR VPWR reg_file.memory\[1\]\[10\] sky130_fd_sc_hd__dfxtp_1
X_3283_ _0947_ reg_file.memory\[10\]\[13\] _0647_ VGND VGND VPWR VPWR _0948_ sky130_fd_sc_hd__mux2_1
X_6071_ clknet_leaf_0_clk _0306_ VGND VGND VPWR VPWR reg_file.memory\[10\]\[5\] sky130_fd_sc_hd__dfxtp_1
X_3352_ reg_file.memory\[0\]\[8\] reg_file.memory\[1\]\[8\] _0590_ VGND VGND VPWR
+ VPWR _1017_ sky130_fd_sc_hd__mux2_1
X_5022_ _2496_ VGND VGND VPWR VPWR _0160_ sky130_fd_sc_hd__clkbuf_1
XFILLER_0_0_42 VPWR VGND VPWR VGND sky130_ef_sc_hd__decap_12
X_5924_ clknet_leaf_18_clk _0159_ VGND VGND VPWR VPWR reg_file.memory\[5\]\[18\] sky130_fd_sc_hd__dfxtp_1
XFILLER_0_90_225 VGND VGND VPWR VPWR sky130_fd_sc_hd__fill_2
X_5855_ clknet_leaf_9_clk _0105_ VGND VGND VPWR VPWR reg_file.memory\[9\]\[29\] sky130_fd_sc_hd__dfxtp_1
X_4737_ clk_div.counter\[15\] clk_div.counter\[14\] _2325_ VGND VGND VPWR VPWR _2328_
+ sky130_fd_sc_hd__and3_1
X_4806_ _2341_ seven_seg_conv.temp\[27\] _1388_ _1389_ VGND VGND VPWR VPWR _0074_
+ sky130_fd_sc_hd__a211o_1
X_2998_ _0662_ VGND VGND VPWR VPWR _0663_ sky130_fd_sc_hd__clkbuf_4
X_5786_ clk_div.slow_clk _0069_ VGND VGND VPWR VPWR seven_seg_conv.temp\[22\] sky130_fd_sc_hd__dfxtp_1
X_4668_ _2281_ _1260_ _2272_ _2282_ _1999_ VGND VGND VPWR VPWR _2283_ sky130_fd_sc_hd__o311a_1
X_4599_ _1902_ _2219_ VGND VGND VPWR VPWR _2220_ sky130_fd_sc_hd__nor2_1
X_3619_ _1283_ _1200_ VGND VGND VPWR VPWR _1284_ sky130_fd_sc_hd__xnor2_1
XTAP_TAPCELL_ROW_8_237 VGND VPWR sky130_fd_sc_hd__tapvpwrvgnd_1
X_6269_ clknet_leaf_5_clk _0504_ VGND VGND VPWR VPWR alu.ALUControl\[0\] sky130_fd_sc_hd__dfxtp_1
XTAP_TAPCELL_ROW_82_684 VGND VPWR sky130_fd_sc_hd__tapvpwrvgnd_1
XFILLER_0_81_214 VGND VGND VPWR VPWR sky130_fd_sc_hd__fill_1
XFILLER_0_81_236 VGND VGND VPWR VPWR sky130_fd_sc_hd__fill_2
XFILLER_0_34_141 VGND VGND VPWR VPWR sky130_fd_sc_hd__fill_1
XFILLER_0_82_16 VPWR VGND VPWR VGND sky130_ef_sc_hd__decap_12
X_3970_ _1353_ VGND VGND VPWR VPWR _1625_ sky130_fd_sc_hd__inv_2
XPHY_EDGE_ROW_13_Right_13 VGND VGND VPWR VPWR sky130_fd_sc_hd__decap_3
X_5640_ _2457_ reg_file.memory\[25\]\[23\] _2819_ VGND VGND VPWR VPWR _2823_ sky130_fd_sc_hd__mux2_1
X_2921_ _0585_ _0542_ VGND VGND VPWR VPWR _0586_ sky130_fd_sc_hd__nand2_1
X_5571_ _2457_ reg_file.memory\[21\]\[23\] _2782_ VGND VGND VPWR VPWR _2786_ sky130_fd_sc_hd__mux2_1
XPHY_EDGE_ROW_22_Right_22 VGND VGND VPWR VPWR sky130_fd_sc_hd__decap_3
X_4384_ _1761_ _1772_ VGND VGND VPWR VPWR _2022_ sky130_fd_sc_hd__and2_1
X_4522_ _1693_ _1696_ VGND VGND VPWR VPWR _2150_ sky130_fd_sc_hd__nand2_1
X_4453_ _2036_ _2085_ _1737_ VGND VGND VPWR VPWR _2086_ sky130_fd_sc_hd__mux2_1
X_3404_ _0571_ _1066_ _1068_ _0605_ VGND VGND VPWR VPWR _1069_ sky130_fd_sc_hd__o211a_1
X_6123_ clknet_leaf_11_clk _0358_ VGND VGND VPWR VPWR reg_file.memory\[15\]\[25\]
+ sky130_fd_sc_hd__dfxtp_1
XFILLER_0_56_83 VGND VGND VPWR VPWR sky130_fd_sc_hd__fill_1
X_3197_ reg_file.memory\[21\]\[18\] _0545_ _0625_ _0861_ VGND VGND VPWR VPWR _0862_
+ sky130_fd_sc_hd__o211ai_4
XPHY_EDGE_ROW_31_Right_31 VGND VGND VPWR VPWR sky130_fd_sc_hd__decap_3
X_6054_ clknet_leaf_17_clk _0289_ VGND VGND VPWR VPWR reg_file.memory\[0\]\[20\] sky130_fd_sc_hd__dfxtp_1
X_3335_ reg_file.memory\[4\]\[9\] reg_file.memory\[5\]\[9\] _0591_ VGND VGND VPWR
+ VPWR _1000_ sky130_fd_sc_hd__mux2_1
XTAP_TAPCELL_ROW_5_218 VGND VPWR sky130_fd_sc_hd__tapvpwrvgnd_1
XFILLER_0_0_296 VGND VGND VPWR VPWR sky130_fd_sc_hd__decap_8
X_3266_ reg_file.memory\[8\]\[14\] reg_file.memory\[9\]\[14\] _0638_ VGND VGND VPWR
+ VPWR _0931_ sky130_fd_sc_hd__mux2_1
X_5005_ _2432_ reg_file.memory\[5\]\[11\] _2486_ VGND VGND VPWR VPWR _2488_ sky130_fd_sc_hd__mux2_1
X_5907_ clknet_leaf_4_clk _0142_ VGND VGND VPWR VPWR reg_file.memory\[5\]\[1\] sky130_fd_sc_hd__dfxtp_1
XFILLER_0_63_225 VGND VGND VPWR VPWR sky130_fd_sc_hd__decap_4
XPHY_EDGE_ROW_40_Right_40 VGND VGND VPWR VPWR sky130_fd_sc_hd__decap_3
XFILLER_0_31_122 VGND VGND VPWR VPWR sky130_fd_sc_hd__decap_6
X_5838_ clknet_leaf_25_clk _0088_ VGND VGND VPWR VPWR reg_file.memory\[9\]\[12\] sky130_fd_sc_hd__dfxtp_1
X_5769_ clk_div.slow_clk _0052_ VGND VGND VPWR VPWR seven_seg_conv.temp\[5\] sky130_fd_sc_hd__dfxtp_1
XFILLER_0_16_185 VGND VGND VPWR VPWR sky130_fd_sc_hd__fill_2
XTAP_TAPCELL_ROW_87_710 VGND VPWR sky130_fd_sc_hd__tapvpwrvgnd_1
XFILLER_0_31_166 VGND VGND VPWR VPWR sky130_fd_sc_hd__fill_2
XTAP_TAPCELL_ROW_70_610 VGND VPWR sky130_fd_sc_hd__tapvpwrvgnd_1
XTAP_TAPCELL_ROW_27_353 VGND VPWR sky130_fd_sc_hd__tapvpwrvgnd_1
XFILLER_0_77_27 VGND VGND VPWR VPWR sky130_fd_sc_hd__fill_2
XTAP_TAPCELL_ROW_10_253 VGND VPWR sky130_fd_sc_hd__tapvpwrvgnd_1
XFILLER_0_89_122 VPWR VGND VPWR VGND sky130_ef_sc_hd__decap_12
X_3120_ reg_file.memory\[0\]\[23\] _0784_ _0656_ VGND VGND VPWR VPWR _0785_ sky130_fd_sc_hd__mux2_1
X_3051_ reg_file.memory\[5\]\[27\] _0715_ _0649_ VGND VGND VPWR VPWR _0716_ sky130_fd_sc_hd__mux2_1
XFILLER_0_89_166 VGND VGND VPWR VPWR sky130_fd_sc_hd__fill_2
X_3953_ _1598_ _1601_ VGND VGND VPWR VPWR _1609_ sky130_fd_sc_hd__or2b_1
X_2904_ PC\[4\] _0568_ VGND VGND VPWR VPWR _0569_ sky130_fd_sc_hd__nand2_2
XFILLER_0_60_217 VGND VGND VPWR VPWR sky130_fd_sc_hd__fill_2
XFILLER_0_45_225 VGND VGND VPWR VPWR sky130_fd_sc_hd__fill_2
XTAP_TAPCELL_ROW_33_389 VGND VPWR sky130_fd_sc_hd__tapvpwrvgnd_1
X_5554_ _2440_ reg_file.memory\[21\]\[15\] _2771_ VGND VGND VPWR VPWR _2777_ sky130_fd_sc_hd__mux2_1
X_5623_ _2440_ reg_file.memory\[25\]\[15\] _2808_ VGND VGND VPWR VPWR _2814_ sky130_fd_sc_hd__mux2_1
X_3884_ _1536_ _1538_ _1539_ VGND VGND VPWR VPWR _1540_ sky130_fd_sc_hd__or3_1
X_4367_ _1968_ _2005_ _1686_ VGND VGND VPWR VPWR _2006_ sky130_fd_sc_hd__mux2_1
X_4436_ _2057_ _2058_ _2070_ VGND VGND VPWR VPWR _0507_ sky130_fd_sc_hd__o21ai_1
X_4505_ _1907_ _2124_ _2125_ _2134_ VGND VGND VPWR VPWR _0512_ sky130_fd_sc_hd__a31o_1
X_6106_ clknet_leaf_2_clk _0341_ VGND VGND VPWR VPWR reg_file.memory\[15\]\[8\] sky130_fd_sc_hd__dfxtp_1
X_3318_ reg_file.memory\[7\]\[10\] _0674_ _0598_ reg_file.memory\[2\]\[10\] _0579_
+ VGND VGND VPWR VPWR _0983_ sky130_fd_sc_hd__o221a_1
XFILLER_0_6_63 VGND VGND VPWR VPWR sky130_fd_sc_hd__decap_3
X_5485_ _2740_ VGND VGND VPWR VPWR _0379_ sky130_fd_sc_hd__clkbuf_1
XFILLER_0_68_306 VGND VGND VPWR VPWR sky130_fd_sc_hd__fill_2
X_4298_ _1924_ VGND VGND VPWR VPWR _1940_ sky130_fd_sc_hd__buf_2
X_6037_ clknet_leaf_1_clk _0272_ VGND VGND VPWR VPWR reg_file.memory\[0\]\[3\] sky130_fd_sc_hd__dfxtp_1
X_3249_ reg_file.memory\[0\]\[15\] _0913_ _0655_ VGND VGND VPWR VPWR _0914_ sky130_fd_sc_hd__mux2_1
XTAP_TAPCELL_ROW_24_334 VGND VPWR sky130_fd_sc_hd__tapvpwrvgnd_1
XFILLER_0_51_206 VPWR VGND VPWR VGND sky130_ef_sc_hd__decap_12
XTAP_TAPCELL_ROW_90_738 VGND VPWR sky130_fd_sc_hd__tapvpwrvgnd_1
X_4221_ _1671_ _1865_ VGND VGND VPWR VPWR _1866_ sky130_fd_sc_hd__nand2_1
X_5270_ _2628_ VGND VGND VPWR VPWR _0276_ sky130_fd_sc_hd__clkbuf_1
X_3034_ reg_file.memory\[6\]\[28\] reg_file.memory\[7\]\[28\] _0641_ VGND VGND VPWR
+ VPWR _0699_ sky130_fd_sc_hd__mux2_1
X_4083_ _1710_ _1728_ VGND VGND VPWR VPWR _1729_ sky130_fd_sc_hd__nand2_1
X_4152_ _1293_ VGND VGND VPWR VPWR _1798_ sky130_fd_sc_hd__inv_2
X_3103_ reg_file.memory\[8\]\[24\] reg_file.memory\[9\]\[24\] _0640_ VGND VGND VPWR
+ VPWR _0768_ sky130_fd_sc_hd__mux2_1
X_4985_ _2477_ VGND VGND VPWR VPWR _0142_ sky130_fd_sc_hd__clkbuf_1
X_3936_ _1579_ _1590_ _1591_ VGND VGND VPWR VPWR _1592_ sky130_fd_sc_hd__a21boi_2
XFILLER_0_18_269 VGND VGND VPWR VPWR sky130_fd_sc_hd__fill_2
XTAP_TAPCELL_ROW_21_315 VGND VPWR sky130_fd_sc_hd__tapvpwrvgnd_1
X_5537_ _2423_ reg_file.memory\[21\]\[7\] _2760_ VGND VGND VPWR VPWR _2768_ sky130_fd_sc_hd__mux2_1
X_5606_ _2423_ reg_file.memory\[25\]\[7\] _2797_ VGND VGND VPWR VPWR _2805_ sky130_fd_sc_hd__mux2_1
X_3867_ _1520_ _1522_ _1516_ VGND VGND VPWR VPWR _1523_ sky130_fd_sc_hd__a21oi_1
X_3798_ _1368_ _1449_ VGND VGND VPWR VPWR _1454_ sky130_fd_sc_hd__xnor2_1
X_4419_ _2001_ _2047_ _2054_ _2041_ VGND VGND VPWR VPWR _2055_ sky130_fd_sc_hd__o211a_1
X_5399_ _2696_ VGND VGND VPWR VPWR _0337_ sky130_fd_sc_hd__clkbuf_1
X_5468_ reg_file.memory\[1\]\[6\] VGND VGND VPWR VPWR _2732_ sky130_fd_sc_hd__clkbuf_1
XFILLER_0_68_125 VGND VGND VPWR VPWR sky130_fd_sc_hd__fill_1
XFILLER_0_74_106 VPWR VGND VPWR VGND sky130_ef_sc_hd__decap_12
XFILLER_0_59_169 VGND VGND VPWR VPWR sky130_fd_sc_hd__decap_3
XTAP_TAPCELL_ROW_43_451 VGND VPWR sky130_fd_sc_hd__tapvpwrvgnd_1
X_4770_ _2341_ seven_seg_conv.temp\[10\] VGND VGND VPWR VPWR _2348_ sky130_fd_sc_hd__nand2_1
XFILLER_0_82_161 VPWR VGND VPWR VGND sky130_ef_sc_hd__decap_12
X_3583_ _0600_ _1247_ VGND VGND VPWR VPWR _1248_ sky130_fd_sc_hd__or2_1
X_3652_ _1267_ _1269_ _1270_ _1316_ VGND VGND VPWR VPWR _1317_ sky130_fd_sc_hd__or4_1
X_3721_ alu.ALUResult\[29\] alu.ALUResult\[31\] VGND VGND VPWR VPWR _1377_ sky130_fd_sc_hd__or2b_1
X_5322_ _2655_ VGND VGND VPWR VPWR _0301_ sky130_fd_sc_hd__clkbuf_1
X_4204_ _1847_ _1848_ VGND VGND VPWR VPWR _1849_ sky130_fd_sc_hd__nand2_1
X_5253_ reg_file.memory\[8\]\[31\] alu.ALUResult\[31\] _2585_ VGND VGND VPWR VPWR
+ _2620_ sky130_fd_sc_hd__mux2_1
X_4135_ _1740_ VGND VGND VPWR VPWR _1781_ sky130_fd_sc_hd__inv_2
X_5184_ _2582_ VGND VGND VPWR VPWR _0236_ sky130_fd_sc_hd__clkbuf_1
X_4066_ _1710_ _1711_ VGND VGND VPWR VPWR _1712_ sky130_fd_sc_hd__nand2_1
X_3017_ reg_file.memory\[21\]\[29\] _0546_ _0626_ _0681_ VGND VGND VPWR VPWR _0682_
+ sky130_fd_sc_hd__o211ai_2
XTAP_TAPCELL_ROW_66_587 VGND VPWR sky130_fd_sc_hd__tapvpwrvgnd_1
XFILLER_0_73_150 VGND VGND VPWR VPWR sky130_fd_sc_hd__decap_6
X_4968_ _2466_ VGND VGND VPWR VPWR _0136_ sky130_fd_sc_hd__clkbuf_1
X_4899_ _2419_ reg_file.memory\[4\]\[5\] _2409_ VGND VGND VPWR VPWR _2420_ sky130_fd_sc_hd__mux2_1
X_3919_ _1568_ _1570_ VGND VGND VPWR VPWR _1575_ sky130_fd_sc_hd__and2_1
XFILLER_0_14_250 VGND VGND VPWR VPWR sky130_fd_sc_hd__fill_2
XTAP_TAPCELL_ROW_57_532 VGND VPWR sky130_fd_sc_hd__tapvpwrvgnd_1
XPHY_EDGE_ROW_69_Right_69 VGND VGND VPWR VPWR sky130_fd_sc_hd__decap_3
XFILLER_0_56_106 VPWR VGND VPWR VGND sky130_ef_sc_hd__decap_12
XFILLER_0_64_172 VGND VGND VPWR VPWR sky130_fd_sc_hd__fill_1
XTAP_TAPCELL_ROW_40_432 VGND VPWR sky130_fd_sc_hd__tapvpwrvgnd_1
XPHY_EDGE_ROW_78_Right_78 VGND VGND VPWR VPWR sky130_fd_sc_hd__decap_3
XPHY_EDGE_ROW_87_Right_87 VGND VGND VPWR VPWR sky130_fd_sc_hd__decap_3
X_5940_ clknet_leaf_4_clk _0175_ VGND VGND VPWR VPWR reg_file.memory\[6\]\[2\] sky130_fd_sc_hd__dfxtp_1
X_5871_ clk_div.slow_clk _0021_ VGND VGND VPWR VPWR seven_seg_conv.digit_counter\[1\]
+ sky130_fd_sc_hd__dfxtp_2
XTAP_TAPCELL_ROW_63_568 VGND VPWR sky130_fd_sc_hd__tapvpwrvgnd_1
XFILLER_0_50_85 VGND VGND VPWR VPWR sky130_fd_sc_hd__decap_4
X_3704_ _1359_ VGND VGND VPWR VPWR _1360_ sky130_fd_sc_hd__inv_2
X_4753_ seven_seg_conv.temp\[3\] _2337_ _2334_ VGND VGND VPWR VPWR _2338_ sky130_fd_sc_hd__mux2_1
X_4822_ reg_file.memory\[9\]\[6\] VGND VGND VPWR VPWR _2375_ sky130_fd_sc_hd__clkbuf_1
X_5305_ reg_file.memory\[0\]\[25\] VGND VGND VPWR VPWR _2646_ sky130_fd_sc_hd__clkbuf_1
XFILLER_0_70_197 VPWR VGND VPWR VGND sky130_ef_sc_hd__decap_12
XFILLER_0_59_72 VGND VGND VPWR VPWR sky130_fd_sc_hd__fill_1
X_3566_ _0729_ _0737_ VGND VGND VPWR VPWR _1231_ sky130_fd_sc_hd__xnor2_1
X_3497_ _0604_ _1160_ _1161_ _0551_ VGND VGND VPWR VPWR _1162_ sky130_fd_sc_hd__a211o_1
X_3635_ _1286_ _1288_ _1297_ _1299_ VGND VGND VPWR VPWR _1300_ sky130_fd_sc_hd__or4_1
X_4684_ _1635_ VGND VGND VPWR VPWR _2296_ sky130_fd_sc_hd__buf_4
X_5167_ _2457_ reg_file.memory\[7\]\[23\] _2570_ VGND VGND VPWR VPWR _2574_ sky130_fd_sc_hd__mux2_1
X_4118_ _1761_ _1763_ VGND VGND VPWR VPWR _1764_ sky130_fd_sc_hd__and2_1
X_5098_ _2537_ VGND VGND VPWR VPWR _0195_ sky130_fd_sc_hd__clkbuf_1
X_5236_ _2611_ VGND VGND VPWR VPWR _0259_ sky130_fd_sc_hd__clkbuf_1
X_4049_ _0884_ _1671_ VGND VGND VPWR VPWR _1695_ sky130_fd_sc_hd__nand2_1
XTAP_TAPCELL_ROW_54_513 VGND VPWR sky130_fd_sc_hd__tapvpwrvgnd_1
XFILLER_0_38_117 VGND VGND VPWR VPWR sky130_fd_sc_hd__fill_2
XFILLER_0_61_142 VGND VGND VPWR VPWR sky130_fd_sc_hd__decap_3
XFILLER_0_46_172 VGND VGND VPWR VPWR sky130_fd_sc_hd__fill_1
XFILLER_0_61_197 VGND VGND VPWR VPWR sky130_fd_sc_hd__decap_3
XFILLER_0_71_18 VGND VGND VPWR VPWR sky130_fd_sc_hd__decap_6
XFILLER_0_84_212 VPWR VGND VPWR VGND sky130_ef_sc_hd__decap_12
XTAP_TAPCELL_ROW_60_549 VGND VPWR sky130_fd_sc_hd__tapvpwrvgnd_1
XFILLER_0_52_120 VGND VGND VPWR VPWR sky130_fd_sc_hd__decap_8
XFILLER_0_52_164 VPWR VGND VPWR VGND sky130_ef_sc_hd__decap_12
X_3420_ reg_file.memory\[4\]\[4\] reg_file.memory\[5\]\[4\] _0589_ VGND VGND VPWR
+ VPWR _1085_ sky130_fd_sc_hd__mux2_1
X_3351_ reg_file.memory\[4\]\[8\] reg_file.memory\[5\]\[8\] _0590_ VGND VGND VPWR
+ VPWR _1016_ sky130_fd_sc_hd__mux2_1
X_5021_ _2448_ reg_file.memory\[5\]\[19\] _2486_ VGND VGND VPWR VPWR _2496_ sky130_fd_sc_hd__mux2_1
X_3282_ reg_file.memory\[8\]\[13\] reg_file.memory\[9\]\[13\] _0638_ VGND VGND VPWR
+ VPWR _0947_ sky130_fd_sc_hd__mux2_1
X_6070_ clknet_leaf_27_clk _0305_ VGND VGND VPWR VPWR reg_file.memory\[10\]\[4\] sky130_fd_sc_hd__dfxtp_1
X_5854_ clknet_leaf_9_clk _0104_ VGND VGND VPWR VPWR reg_file.memory\[9\]\[28\] sky130_fd_sc_hd__dfxtp_1
XFILLER_0_0_54 VGND VGND VPWR VPWR sky130_fd_sc_hd__fill_2
X_5923_ clknet_leaf_19_clk _0158_ VGND VGND VPWR VPWR reg_file.memory\[5\]\[17\] sky130_fd_sc_hd__dfxtp_1
XFILLER_0_90_259 VGND VGND VPWR VPWR sky130_fd_sc_hd__fill_1
X_4736_ clk_div.counter\[14\] _2325_ VGND VGND VPWR VPWR _0043_ sky130_fd_sc_hd__xor2_1
X_2997_ _0660_ _0661_ _0585_ VGND VGND VPWR VPWR _0662_ sky130_fd_sc_hd__a21oi_4
X_4667_ _2281_ _2272_ _1260_ VGND VGND VPWR VPWR _2282_ sky130_fd_sc_hd__o21ai_1
X_4805_ _2340_ seven_seg_conv.temp\[26\] _1392_ VGND VGND VPWR VPWR _0073_ sky130_fd_sc_hd__a21o_1
X_5785_ clk_div.slow_clk _0068_ VGND VGND VPWR VPWR seven_seg_conv.temp\[21\] sky130_fd_sc_hd__dfxtp_1
X_6268_ clknet_leaf_5_clk _0503_ VGND VGND VPWR VPWR alu.ALUControl\[1\] sky130_fd_sc_hd__dfxtp_2
X_4598_ _1268_ _2218_ VGND VGND VPWR VPWR _2219_ sky130_fd_sc_hd__xnor2_1
X_3618_ _1014_ _1198_ VGND VGND VPWR VPWR _1283_ sky130_fd_sc_hd__nand2_1
X_3549_ _0877_ _0884_ VGND VGND VPWR VPWR _1214_ sky130_fd_sc_hd__nor2_1
XFILLER_0_31_337 VGND VGND VPWR VPWR sky130_fd_sc_hd__fill_2
XTAP_TAPCELL_ROW_8_238 VGND VPWR sky130_fd_sc_hd__tapvpwrvgnd_1
X_6199_ clknet_leaf_2_clk _0434_ VGND VGND VPWR VPWR reg_file.memory\[25\]\[5\] sky130_fd_sc_hd__dfxtp_1
X_5219_ _2602_ VGND VGND VPWR VPWR _0251_ sky130_fd_sc_hd__clkbuf_1
XTAP_TAPCELL_ROW_82_685 VGND VPWR sky130_fd_sc_hd__tapvpwrvgnd_1
X_2920_ PC\[4\] _0558_ VGND VGND VPWR VPWR _0585_ sky130_fd_sc_hd__nor2_2
XTAP_TAPCELL_ROW_73_630 VGND VPWR sky130_fd_sc_hd__tapvpwrvgnd_1
XFILLER_0_57_223 VGND VGND VPWR VPWR sky130_fd_sc_hd__fill_1
XFILLER_0_72_248 VGND VGND VPWR VPWR sky130_fd_sc_hd__fill_1
XFILLER_0_57_278 VGND VGND VPWR VPWR sky130_fd_sc_hd__fill_2
X_5570_ _2785_ VGND VGND VPWR VPWR _0419_ sky130_fd_sc_hd__clkbuf_1
X_4521_ _1307_ _2059_ VGND VGND VPWR VPWR _2149_ sky130_fd_sc_hd__nor2_1
XPHY_EDGE_ROW_28_Left_119 VGND VGND VPWR VPWR sky130_fd_sc_hd__decap_3
X_4452_ _2061_ _2084_ _1719_ VGND VGND VPWR VPWR _2085_ sky130_fd_sc_hd__mux2_1
X_6122_ clknet_leaf_13_clk _0357_ VGND VGND VPWR VPWR reg_file.memory\[15\]\[24\]
+ sky130_fd_sc_hd__dfxtp_1
X_4383_ _2020_ VGND VGND VPWR VPWR _2021_ sky130_fd_sc_hd__inv_2
X_3334_ reg_file.memory\[2\]\[9\] _0566_ _0572_ reg_file.memory\[7\]\[9\] _0579_ VGND
+ VGND VPWR VPWR _0999_ sky130_fd_sc_hd__o221a_1
X_3403_ _0597_ _1067_ VGND VGND VPWR VPWR _1068_ sky130_fd_sc_hd__or2_1
XTAP_TAPCELL_ROW_5_219 VGND VPWR sky130_fd_sc_hd__tapvpwrvgnd_1
XFILLER_0_0_253 VGND VGND VPWR VPWR sky130_fd_sc_hd__fill_2
XFILLER_0_56_40 VGND VGND VPWR VPWR sky130_fd_sc_hd__fill_2
XPHY_EDGE_ROW_37_Left_128 VGND VGND VPWR VPWR sky130_fd_sc_hd__decap_3
X_3196_ reg_file.memory\[15\]\[18\] _0553_ _0617_ _0860_ VGND VGND VPWR VPWR _0861_
+ sky130_fd_sc_hd__a211o_1
X_5004_ _2487_ VGND VGND VPWR VPWR _0151_ sky130_fd_sc_hd__clkbuf_1
X_3265_ reg_file.memory\[0\]\[14\] _0929_ _0655_ VGND VGND VPWR VPWR _0930_ sky130_fd_sc_hd__mux2_1
XFILLER_0_15_3 VGND VGND VPWR VPWR sky130_fd_sc_hd__fill_1
X_6053_ clknet_leaf_17_clk _0288_ VGND VGND VPWR VPWR reg_file.memory\[0\]\[19\] sky130_fd_sc_hd__dfxtp_1
X_5906_ clknet_leaf_4_clk _0141_ VGND VGND VPWR VPWR reg_file.memory\[5\]\[0\] sky130_fd_sc_hd__dfxtp_1
XPHY_EDGE_ROW_46_Left_137 VGND VGND VPWR VPWR sky130_fd_sc_hd__decap_3
X_5837_ clknet_leaf_25_clk _0087_ VGND VGND VPWR VPWR reg_file.memory\[9\]\[11\] sky130_fd_sc_hd__dfxtp_1
X_4719_ _2302_ _2315_ _2317_ VGND VGND VPWR VPWR _2318_ sky130_fd_sc_hd__and3_1
XFILLER_0_71_281 VGND VGND VPWR VPWR sky130_fd_sc_hd__fill_1
X_5699_ _2852_ VGND VGND VPWR VPWR _0481_ sky130_fd_sc_hd__clkbuf_1
X_5768_ clk_div.slow_clk _0051_ VGND VGND VPWR VPWR seven_seg_conv.temp\[4\] sky130_fd_sc_hd__dfxtp_1
XTAP_TAPCELL_ROW_87_711 VGND VPWR sky130_fd_sc_hd__tapvpwrvgnd_1
XPHY_EDGE_ROW_55_Left_146 VGND VGND VPWR VPWR sky130_fd_sc_hd__decap_3
XTAP_TAPCELL_ROW_70_611 VGND VPWR sky130_fd_sc_hd__tapvpwrvgnd_1
XPHY_EDGE_ROW_64_Left_155 VGND VGND VPWR VPWR sky130_fd_sc_hd__decap_3
XFILLER_0_39_234 VGND VGND VPWR VPWR sky130_fd_sc_hd__fill_2
XTAP_TAPCELL_ROW_27_354 VGND VPWR sky130_fd_sc_hd__tapvpwrvgnd_1
XFILLER_0_54_259 VGND VGND VPWR VPWR sky130_fd_sc_hd__fill_1
XFILLER_0_39_278 VGND VGND VPWR VPWR sky130_fd_sc_hd__fill_2
XPHY_EDGE_ROW_73_Left_164 VGND VGND VPWR VPWR sky130_fd_sc_hd__decap_3
XFILLER_0_22_178 VGND VGND VPWR VPWR sky130_fd_sc_hd__fill_1
XFILLER_0_89_134 VPWR VGND VPWR VGND sky130_ef_sc_hd__decap_12
XFILLER_0_89_101 VGND VGND VPWR VPWR sky130_fd_sc_hd__decap_8
X_3050_ reg_file.memory\[6\]\[27\] reg_file.memory\[7\]\[27\] _0640_ VGND VGND VPWR
+ VPWR _0715_ sky130_fd_sc_hd__mux2_1
XPHY_EDGE_ROW_82_Left_173 VGND VGND VPWR VPWR sky130_fd_sc_hd__decap_3
X_2903_ _0549_ _0559_ VGND VGND VPWR VPWR _0568_ sky130_fd_sc_hd__nand2_1
X_3952_ _1605_ _1606_ _1607_ VGND VGND VPWR VPWR _1608_ sky130_fd_sc_hd__a21bo_1
X_3883_ _1534_ _1531_ VGND VGND VPWR VPWR _1539_ sky130_fd_sc_hd__and2_1
X_4504_ _1952_ _2132_ _2133_ _1954_ _1272_ VGND VGND VPWR VPWR _2134_ sky130_fd_sc_hd__a32o_1
X_5553_ _2776_ VGND VGND VPWR VPWR _0411_ sky130_fd_sc_hd__clkbuf_1
X_5622_ _2813_ VGND VGND VPWR VPWR _0443_ sky130_fd_sc_hd__clkbuf_1
X_5484_ reg_file.memory\[1\]\[14\] VGND VGND VPWR VPWR _2740_ sky130_fd_sc_hd__clkbuf_1
X_4297_ _1789_ _1780_ VGND VGND VPWR VPWR _1939_ sky130_fd_sc_hd__nand2_1
X_4366_ _1838_ _1840_ VGND VGND VPWR VPWR _2005_ sky130_fd_sc_hd__nand2_1
X_4435_ _1282_ _2059_ _2067_ _2069_ VGND VGND VPWR VPWR _2070_ sky130_fd_sc_hd__o22a_1
X_3317_ _0974_ _0981_ VGND VGND VPWR VPWR _0982_ sky130_fd_sc_hd__nand2_1
X_6105_ clknet_leaf_2_clk _0340_ VGND VGND VPWR VPWR reg_file.memory\[15\]\[7\] sky130_fd_sc_hd__dfxtp_1
X_6036_ clknet_leaf_4_clk _0271_ VGND VGND VPWR VPWR reg_file.memory\[0\]\[2\] sky130_fd_sc_hd__dfxtp_1
X_3179_ _0839_ _0843_ _0611_ VGND VGND VPWR VPWR _0844_ sky130_fd_sc_hd__o21a_1
X_3248_ reg_file.memory\[5\]\[15\] _0912_ _0647_ VGND VGND VPWR VPWR _0913_ sky130_fd_sc_hd__mux2_1
XFILLER_0_51_229 VGND VGND VPWR VPWR sky130_fd_sc_hd__fill_1
XFILLER_0_51_218 VGND VGND VPWR VPWR sky130_fd_sc_hd__decap_6
XTAP_TAPCELL_ROW_24_335 VGND VPWR sky130_fd_sc_hd__tapvpwrvgnd_1
XFILLER_0_4_3 VGND VGND VPWR VPWR sky130_fd_sc_hd__decap_8
XTAP_TAPCELL_ROW_90_739 VGND VPWR sky130_fd_sc_hd__tapvpwrvgnd_1
XTAP_TAPCELL_ROW_90_728 VGND VPWR sky130_fd_sc_hd__tapvpwrvgnd_1
XFILLER_0_50_251 VGND VGND VPWR VPWR sky130_fd_sc_hd__fill_1
XFILLER_0_42_229 VGND VGND VPWR VPWR sky130_fd_sc_hd__decap_4
X_4220_ _1152_ _1675_ _1864_ VGND VGND VPWR VPWR _1865_ sky130_fd_sc_hd__a21bo_1
X_4151_ _1796_ VGND VGND VPWR VPWR _1797_ sky130_fd_sc_hd__clkbuf_4
X_3033_ reg_file.memory\[21\]\[28\] _0545_ _0626_ _0697_ VGND VGND VPWR VPWR _0698_
+ sky130_fd_sc_hd__o211ai_2
X_4082_ _0771_ _1671_ VGND VGND VPWR VPWR _1728_ sky130_fd_sc_hd__nand2_1
X_3102_ reg_file.memory\[0\]\[24\] _0766_ _0656_ VGND VGND VPWR VPWR _0767_ sky130_fd_sc_hd__mux2_1
XTAP_TAPCELL_ROW_38_416 VGND VPWR sky130_fd_sc_hd__tapvpwrvgnd_1
X_4984_ _2411_ reg_file.memory\[5\]\[1\] _2475_ VGND VGND VPWR VPWR _2477_ sky130_fd_sc_hd__mux2_1
XFILLER_0_58_362 VGND VGND VPWR VPWR sky130_fd_sc_hd__fill_2
X_5605_ _2804_ VGND VGND VPWR VPWR _0435_ sky130_fd_sc_hd__clkbuf_1
XFILLER_0_5_120 VGND VGND VPWR VPWR sky130_fd_sc_hd__decap_6
X_3866_ _1508_ _1514_ _1521_ VGND VGND VPWR VPWR _1522_ sky130_fd_sc_hd__a21oi_1
X_3935_ _1590_ _1582_ VGND VGND VPWR VPWR _1591_ sky130_fd_sc_hd__nand2b_1
XTAP_TAPCELL_ROW_21_316 VGND VPWR sky130_fd_sc_hd__tapvpwrvgnd_1
XFILLER_0_82_3 VGND VGND VPWR VPWR sky130_fd_sc_hd__decap_8
XFILLER_0_78_82 VGND VGND VPWR VPWR sky130_fd_sc_hd__fill_2
X_4418_ _1743_ _2052_ _2053_ VGND VGND VPWR VPWR _2054_ sky130_fd_sc_hd__or3b_1
X_5536_ _2767_ VGND VGND VPWR VPWR _0403_ sky130_fd_sc_hd__clkbuf_1
X_5467_ _2731_ VGND VGND VPWR VPWR _0370_ sky130_fd_sc_hd__clkbuf_1
X_3797_ _1367_ VGND VGND VPWR VPWR _1453_ sky130_fd_sc_hd__inv_2
X_4349_ _1845_ _1980_ _1981_ _1986_ _1988_ VGND VGND VPWR VPWR _1989_ sky130_fd_sc_hd__a311o_1
X_5398_ _2417_ reg_file.memory\[15\]\[4\] _2691_ VGND VGND VPWR VPWR _2696_ sky130_fd_sc_hd__mux2_1
X_6019_ clknet_leaf_18_clk _0254_ VGND VGND VPWR VPWR reg_file.memory\[8\]\[17\] sky130_fd_sc_hd__dfxtp_1
XFILLER_0_68_137 VGND VGND VPWR VPWR sky130_fd_sc_hd__decap_3
XFILLER_0_76_192 VGND VGND VPWR VPWR sky130_fd_sc_hd__decap_4
XFILLER_0_74_29 VGND VGND VPWR VPWR sky130_fd_sc_hd__fill_1
XFILLER_0_74_18 VGND VGND VPWR VPWR sky130_fd_sc_hd__fill_1
XFILLER_0_74_118 VPWR VGND VPWR VGND sky130_ef_sc_hd__decap_12
XFILLER_0_67_181 VPWR VGND VPWR VGND sky130_ef_sc_hd__decap_12
X_3720_ alu.ALUResult\[30\] VGND VGND VPWR VPWR _1376_ sky130_fd_sc_hd__buf_4
XFILLER_0_15_207 VGND VGND VPWR VPWR sky130_fd_sc_hd__fill_1
XFILLER_0_82_184 VGND VGND VPWR VPWR sky130_fd_sc_hd__fill_1
XFILLER_0_82_173 VGND VGND VPWR VPWR sky130_fd_sc_hd__decap_6
X_3582_ reg_file.memory\[0\]\[31\] reg_file.memory\[1\]\[31\] _0594_ VGND VGND VPWR
+ VPWR _1247_ sky130_fd_sc_hd__mux2_1
X_3651_ _1271_ _1311_ _1312_ _1315_ VGND VGND VPWR VPWR _1316_ sky130_fd_sc_hd__or4b_1
X_5321_ reg_file.memory\[10\]\[0\] alu.ALUResult\[0\] _2654_ VGND VGND VPWR VPWR _2655_
+ sky130_fd_sc_hd__mux2_1
XFILLER_0_23_284 VGND VGND VPWR VPWR sky130_fd_sc_hd__fill_2
X_4134_ _1773_ _1778_ _1779_ VGND VGND VPWR VPWR _1780_ sky130_fd_sc_hd__mux2_1
X_5252_ _2619_ VGND VGND VPWR VPWR _0267_ sky130_fd_sc_hd__clkbuf_1
X_4203_ _1675_ _1745_ VGND VGND VPWR VPWR _1848_ sky130_fd_sc_hd__nand2_1
X_5183_ _2367_ reg_file.memory\[7\]\[31\] _2547_ VGND VGND VPWR VPWR _2582_ sky130_fd_sc_hd__mux2_1
XFILLER_0_48_85 VGND VGND VPWR VPWR sky130_fd_sc_hd__decap_4
X_4065_ _0672_ _1697_ VGND VGND VPWR VPWR _1711_ sky130_fd_sc_hd__nand2_1
X_3016_ reg_file.memory\[15\]\[29\] _0554_ _0618_ _0680_ VGND VGND VPWR VPWR _0681_
+ sky130_fd_sc_hd__a211o_1
XTAP_TAPCELL_ROW_66_588 VGND VPWR sky130_fd_sc_hd__tapvpwrvgnd_1
XFILLER_0_80_61 VPWR VGND VPWR VGND sky130_ef_sc_hd__decap_12
XFILLER_0_61_335 VGND VGND VPWR VPWR sky130_fd_sc_hd__fill_1
X_4967_ _2465_ reg_file.memory\[4\]\[27\] _2451_ VGND VGND VPWR VPWR _2466_ sky130_fd_sc_hd__mux2_1
X_4898_ alu.ALUResult\[5\] VGND VGND VPWR VPWR _2419_ sky130_fd_sc_hd__dlymetal6s2s_1
X_3849_ _1496_ _1493_ _1491_ VGND VGND VPWR VPWR _1505_ sky130_fd_sc_hd__mux2_1
X_3918_ _1568_ _1570_ _1572_ _1573_ VGND VGND VPWR VPWR _1574_ sky130_fd_sc_hd__a22o_1
X_5519_ _2757_ VGND VGND VPWR VPWR _0396_ sky130_fd_sc_hd__clkbuf_1
XTAP_TAPCELL_ROW_57_533 VGND VPWR sky130_fd_sc_hd__tapvpwrvgnd_1
XFILLER_0_56_118 VPWR VGND VPWR VGND sky130_ef_sc_hd__decap_12
XTAP_TAPCELL_ROW_40_433 VGND VPWR sky130_fd_sc_hd__tapvpwrvgnd_1
Xclkbuf_leaf_22_clk clknet_1_0__leaf_clk VGND VGND VPWR VPWR clknet_leaf_22_clk sky130_fd_sc_hd__clkbuf_8
XFILLER_0_64_195 VGND VGND VPWR VPWR sky130_fd_sc_hd__fill_1
X_5870_ clk_div.slow_clk _0020_ VGND VGND VPWR VPWR seven_seg_conv.digit_counter\[0\]
+ sky130_fd_sc_hd__dfxtp_2
XTAP_TAPCELL_ROW_63_569 VGND VPWR sky130_fd_sc_hd__tapvpwrvgnd_1
XFILLER_0_34_32 VGND VGND VPWR VPWR sky130_fd_sc_hd__fill_2
X_4821_ _2374_ VGND VGND VPWR VPWR _0081_ sky130_fd_sc_hd__clkbuf_1
X_4683_ _2294_ _2295_ VGND VGND VPWR VPWR _0022_ sky130_fd_sc_hd__nor2_1
Xclkbuf_leaf_13_clk clknet_1_1__leaf_clk VGND VGND VPWR VPWR clknet_leaf_13_clk sky130_fd_sc_hd__clkbuf_8
X_3634_ _1298_ _1194_ VGND VGND VPWR VPWR _1299_ sky130_fd_sc_hd__xnor2_1
XFILLER_0_43_335 VGND VGND VPWR VPWR sky130_fd_sc_hd__fill_1
X_3703_ seven_seg_conv.temp\[10\] alu.ALUResult\[10\] _1347_ VGND VGND VPWR VPWR _1359_
+ sky130_fd_sc_hd__mux2_1
X_4752_ _1595_ _1592_ VGND VGND VPWR VPWR _2337_ sky130_fd_sc_hd__nand2_1
X_5304_ _2645_ VGND VGND VPWR VPWR _0293_ sky130_fd_sc_hd__clkbuf_1
X_3565_ _0746_ _0754_ VGND VGND VPWR VPWR _1230_ sky130_fd_sc_hd__and2_1
X_3496_ reg_file.memory\[2\]\[0\] _0565_ _0570_ reg_file.memory\[7\]\[0\] _0578_ VGND
+ VGND VPWR VPWR _1161_ sky130_fd_sc_hd__o221a_1
X_5235_ reg_file.memory\[8\]\[22\] alu.ALUResult\[22\] _2608_ VGND VGND VPWR VPWR
+ _2611_ sky130_fd_sc_hd__mux2_1
X_4048_ _1691_ _1693_ VGND VGND VPWR VPWR _1694_ sky130_fd_sc_hd__nand2_1
X_4117_ _1674_ _1762_ VGND VGND VPWR VPWR _1763_ sky130_fd_sc_hd__or2_1
X_5097_ _2455_ reg_file.memory\[6\]\[22\] _2534_ VGND VGND VPWR VPWR _2537_ sky130_fd_sc_hd__mux2_1
X_5166_ _2573_ VGND VGND VPWR VPWR _0227_ sky130_fd_sc_hd__clkbuf_1
X_5999_ clknet_leaf_10_clk _0234_ VGND VGND VPWR VPWR reg_file.memory\[7\]\[29\] sky130_fd_sc_hd__dfxtp_1
XTAP_TAPCELL_ROW_54_514 VGND VPWR sky130_fd_sc_hd__tapvpwrvgnd_1
XFILLER_0_61_132 VGND VGND VPWR VPWR sky130_fd_sc_hd__decap_3
XFILLER_0_61_121 VGND VGND VPWR VPWR sky130_fd_sc_hd__decap_8
XFILLER_0_46_195 VGND VGND VPWR VPWR sky130_fd_sc_hd__fill_1
XFILLER_0_84_246 VGND VGND VPWR VPWR sky130_fd_sc_hd__decap_6
XFILLER_0_84_224 VGND VGND VPWR VPWR sky130_fd_sc_hd__fill_2
XFILLER_0_52_132 VGND VGND VPWR VPWR sky130_fd_sc_hd__decap_8
XFILLER_0_52_176 VGND VGND VPWR VPWR sky130_fd_sc_hd__decap_8
X_3350_ reg_file.memory\[2\]\[8\] _0566_ _0571_ reg_file.memory\[7\]\[8\] _0579_ VGND
+ VGND VPWR VPWR _1015_ sky130_fd_sc_hd__o221a_1
Xclkbuf_leaf_2_clk clknet_1_0__leaf_clk VGND VGND VPWR VPWR clknet_leaf_2_clk sky130_fd_sc_hd__clkbuf_8
XFILLER_0_29_87 VGND VGND VPWR VPWR sky130_fd_sc_hd__fill_2
X_3281_ reg_file.memory\[0\]\[13\] _0945_ _0655_ VGND VGND VPWR VPWR _0946_ sky130_fd_sc_hd__mux2_1
X_5020_ _2495_ VGND VGND VPWR VPWR _0159_ sky130_fd_sc_hd__clkbuf_1
XFILLER_0_90_205 VGND VGND VPWR VPWR sky130_fd_sc_hd__decap_3
X_5853_ clknet_leaf_9_clk _0103_ VGND VGND VPWR VPWR reg_file.memory\[9\]\[27\] sky130_fd_sc_hd__dfxtp_1
XFILLER_0_75_279 VGND VGND VPWR VPWR sky130_fd_sc_hd__fill_1
XFILLER_0_75_213 VGND VGND VPWR VPWR sky130_fd_sc_hd__decap_3
X_4804_ _2340_ seven_seg_conv.temp\[25\] _2366_ VGND VGND VPWR VPWR _0072_ sky130_fd_sc_hd__a21o_1
X_5784_ clk_div.slow_clk _0067_ VGND VGND VPWR VPWR seven_seg_conv.temp\[20\] sky130_fd_sc_hd__dfxtp_1
X_5922_ clknet_leaf_19_clk _0157_ VGND VGND VPWR VPWR reg_file.memory\[5\]\[16\] sky130_fd_sc_hd__dfxtp_1
X_4735_ _2327_ VGND VGND VPWR VPWR _0042_ sky130_fd_sc_hd__clkbuf_1
X_2996_ _0547_ _0620_ VGND VGND VPWR VPWR _0661_ sky130_fd_sc_hd__or2_1
X_4666_ _0627_ _0672_ VGND VGND VPWR VPWR _2281_ sky130_fd_sc_hd__and2b_1
X_4597_ _2217_ _0771_ _2207_ VGND VGND VPWR VPWR _2218_ sky130_fd_sc_hd__a21oi_1
X_3617_ _1204_ _1281_ VGND VGND VPWR VPWR _1282_ sky130_fd_sc_hd__nand2_1
XFILLER_0_43_187 VGND VGND VPWR VPWR sky130_fd_sc_hd__fill_1
XFILLER_0_9_53 VGND VGND VPWR VPWR sky130_fd_sc_hd__decap_3
X_6267_ clknet_leaf_7_clk _0502_ VGND VGND VPWR VPWR alu.ALUControl\[2\] sky130_fd_sc_hd__dfxtp_2
X_3479_ reg_file.memory\[21\]\[1\] _0615_ _1142_ _1143_ _1055_ VGND VGND VPWR VPWR
+ _1144_ sky130_fd_sc_hd__a221o_1
X_3548_ _0903_ _1212_ VGND VGND VPWR VPWR _1213_ sky130_fd_sc_hd__or2_1
X_6198_ clknet_leaf_1_clk _0433_ VGND VGND VPWR VPWR reg_file.memory\[25\]\[4\] sky130_fd_sc_hd__dfxtp_1
X_5218_ reg_file.memory\[8\]\[14\] alu.ALUResult\[14\] _2597_ VGND VGND VPWR VPWR
+ _2602_ sky130_fd_sc_hd__mux2_1
XTAP_TAPCELL_ROW_8_239 VGND VPWR sky130_fd_sc_hd__tapvpwrvgnd_1
X_5149_ _2564_ VGND VGND VPWR VPWR _0219_ sky130_fd_sc_hd__clkbuf_1
XFILLER_0_22_327 VGND VGND VPWR VPWR sky130_fd_sc_hd__fill_2
XFILLER_0_82_29 VGND VGND VPWR VPWR sky130_fd_sc_hd__decap_4
XTAP_TAPCELL_ROW_73_631 VGND VPWR sky130_fd_sc_hd__tapvpwrvgnd_1
XFILLER_0_80_260 VGND VGND VPWR VPWR sky130_fd_sc_hd__fill_1
XFILLER_0_72_216 VGND VGND VPWR VPWR sky130_fd_sc_hd__decap_8
X_4451_ _1851_ _1854_ VGND VGND VPWR VPWR _2084_ sky130_fd_sc_hd__nand2_1
XFILLER_0_65_290 VGND VGND VPWR VPWR sky130_fd_sc_hd__fill_1
X_4520_ _1217_ _2147_ VGND VGND VPWR VPWR _2148_ sky130_fd_sc_hd__xnor2_1
XFILLER_0_31_99 VGND VGND VPWR VPWR sky130_fd_sc_hd__fill_1
XFILLER_0_31_55 VGND VGND VPWR VPWR sky130_fd_sc_hd__fill_1
X_6121_ clknet_leaf_9_clk _0356_ VGND VGND VPWR VPWR reg_file.memory\[15\]\[23\] sky130_fd_sc_hd__dfxtp_1
X_4382_ _1108_ _1741_ VGND VGND VPWR VPWR _2020_ sky130_fd_sc_hd__or2_1
X_3333_ _0990_ _0997_ VGND VGND VPWR VPWR _0998_ sky130_fd_sc_hd__nand2_1
X_3402_ reg_file.memory\[0\]\[5\] reg_file.memory\[1\]\[5\] _0589_ VGND VGND VPWR
+ VPWR _1067_ sky130_fd_sc_hd__mux2_1
XPHY_EDGE_ROW_7_Right_7 VGND VGND VPWR VPWR sky130_fd_sc_hd__decap_3
X_3264_ reg_file.memory\[5\]\[14\] _0928_ _0647_ VGND VGND VPWR VPWR _0929_ sky130_fd_sc_hd__mux2_1
X_6052_ clknet_leaf_18_clk _0287_ VGND VGND VPWR VPWR reg_file.memory\[0\]\[18\] sky130_fd_sc_hd__dfxtp_1
X_5003_ _2429_ reg_file.memory\[5\]\[10\] _2486_ VGND VGND VPWR VPWR _2487_ sky130_fd_sc_hd__mux2_1
X_3195_ _0855_ _0859_ _0611_ VGND VGND VPWR VPWR _0860_ sky130_fd_sc_hd__o21a_1
X_2979_ _0538_ _0561_ _0643_ PC\[4\] VGND VGND VPWR VPWR _0644_ sky130_fd_sc_hd__a22o_4
X_5905_ clknet_leaf_13_clk _0140_ VGND VGND VPWR VPWR reg_file.memory\[4\]\[31\] sky130_fd_sc_hd__dfxtp_1
X_5836_ clknet_leaf_25_clk _0086_ VGND VGND VPWR VPWR reg_file.memory\[9\]\[10\] sky130_fd_sc_hd__dfxtp_1
X_5767_ clk_div.slow_clk _0050_ VGND VGND VPWR VPWR seven_seg_conv.temp\[3\] sky130_fd_sc_hd__dfxtp_1
X_4718_ _2316_ VGND VGND VPWR VPWR _2317_ sky130_fd_sc_hd__inv_2
X_4649_ _1963_ _1820_ _1817_ _1816_ VGND VGND VPWR VPWR _2266_ sky130_fd_sc_hd__a31o_1
X_5698_ reg_file.memory\[2\]\[20\] VGND VGND VPWR VPWR _2852_ sky130_fd_sc_hd__clkbuf_1
XTAP_TAPCELL_ROW_87_712 VGND VPWR sky130_fd_sc_hd__tapvpwrvgnd_1
XTAP_TAPCELL_ROW_70_612 VGND VPWR sky130_fd_sc_hd__tapvpwrvgnd_1
XTAP_TAPCELL_ROW_27_355 VGND VPWR sky130_fd_sc_hd__tapvpwrvgnd_1
XFILLER_0_54_227 VGND VGND VPWR VPWR sky130_fd_sc_hd__decap_4
XFILLER_0_47_290 VGND VGND VPWR VPWR sky130_fd_sc_hd__decap_4
XFILLER_0_89_146 VPWR VGND VPWR VGND sky130_ef_sc_hd__decap_12
XTAP_TAPCELL_ROW_18_300 VGND VPWR sky130_fd_sc_hd__tapvpwrvgnd_1
XFILLER_0_42_98 VGND VGND VPWR VPWR sky130_fd_sc_hd__fill_1
X_5621_ _2438_ reg_file.memory\[25\]\[14\] _2808_ VGND VGND VPWR VPWR _2813_ sky130_fd_sc_hd__mux2_1
X_2902_ _0566_ VGND VGND VPWR VPWR _0567_ sky130_fd_sc_hd__clkbuf_4
X_3882_ _1525_ _1537_ _1533_ VGND VGND VPWR VPWR _1538_ sky130_fd_sc_hd__o21a_1
X_3951_ _1355_ _1589_ _1592_ _1596_ VGND VGND VPWR VPWR _1607_ sky130_fd_sc_hd__a31o_1
XFILLER_0_53_260 VGND VGND VPWR VPWR sky130_fd_sc_hd__fill_1
X_4503_ _1738_ _1740_ _1742_ _1800_ VGND VGND VPWR VPWR _2133_ sky130_fd_sc_hd__a31o_1
X_4434_ _1800_ _2068_ _1952_ VGND VGND VPWR VPWR _2069_ sky130_fd_sc_hd__o21ai_1
X_5552_ _2438_ reg_file.memory\[21\]\[14\] _2771_ VGND VGND VPWR VPWR _2776_ sky130_fd_sc_hd__mux2_1
XFILLER_0_5_335 VGND VGND VPWR VPWR sky130_fd_sc_hd__fill_1
XFILLER_0_13_102 VGND VGND VPWR VPWR sky130_fd_sc_hd__fill_1
XFILLER_0_13_157 VGND VGND VPWR VPWR sky130_fd_sc_hd__fill_2
X_5483_ _2739_ VGND VGND VPWR VPWR _0378_ sky130_fd_sc_hd__clkbuf_1
X_4365_ _1738_ _1950_ _1915_ _2003_ VGND VGND VPWR VPWR _2004_ sky130_fd_sc_hd__a31o_1
X_4296_ _1816_ _1765_ VGND VGND VPWR VPWR _1938_ sky130_fd_sc_hd__nand2_1
X_6035_ clknet_leaf_5_clk _0270_ VGND VGND VPWR VPWR reg_file.memory\[0\]\[1\] sky130_fd_sc_hd__dfxtp_1
X_6104_ clknet_leaf_2_clk _0339_ VGND VGND VPWR VPWR reg_file.memory\[15\]\[6\] sky130_fd_sc_hd__dfxtp_1
X_3316_ reg_file.memory\[25\]\[11\] _0980_ _0669_ VGND VGND VPWR VPWR _0981_ sky130_fd_sc_hd__mux2_2
X_3247_ reg_file.memory\[6\]\[15\] reg_file.memory\[7\]\[15\] _0638_ VGND VGND VPWR
+ VPWR _0912_ sky130_fd_sc_hd__mux2_1
XFILLER_0_83_72 VPWR VGND VPWR VGND sky130_ef_sc_hd__decap_12
X_3178_ _0574_ _0840_ _0842_ _0606_ VGND VGND VPWR VPWR _0843_ sky130_fd_sc_hd__o211a_1
XFILLER_0_76_363 VGND VGND VPWR VPWR sky130_fd_sc_hd__fill_1
X_5819_ _0522_ _0014_ VGND VGND VPWR VPWR alu.ALUResult\[25\] sky130_fd_sc_hd__dlxtn_1
XTAP_TAPCELL_ROW_32_380 VGND VPWR sky130_fd_sc_hd__tapvpwrvgnd_1
XTAP_TAPCELL_ROW_24_336 VGND VPWR sky130_fd_sc_hd__tapvpwrvgnd_1
XFILLER_0_59_308 VGND VGND VPWR VPWR sky130_fd_sc_hd__fill_1
XTAP_TAPCELL_ROW_90_729 VGND VPWR sky130_fd_sc_hd__tapvpwrvgnd_1
XFILLER_0_2_349 VPWR VGND VPWR VGND sky130_ef_sc_hd__decap_12
XFILLER_0_12_46 VPWR VGND VPWR VGND sky130_ef_sc_hd__decap_12
X_4081_ _1659_ _1726_ VGND VGND VPWR VPWR _1727_ sky130_fd_sc_hd__nand2_1
X_3101_ reg_file.memory\[5\]\[24\] _0765_ _0649_ VGND VGND VPWR VPWR _0766_ sky130_fd_sc_hd__mux2_1
X_4150_ _1072_ _1795_ VGND VGND VPWR VPWR _1796_ sky130_fd_sc_hd__nor2_1
XFILLER_0_37_10 VGND VGND VPWR VPWR sky130_fd_sc_hd__fill_2
X_3032_ reg_file.memory\[15\]\[28\] _0554_ _0618_ _0696_ VGND VGND VPWR VPWR _0697_
+ sky130_fd_sc_hd__a211o_1
XFILLER_0_58_352 VGND VGND VPWR VPWR sky130_fd_sc_hd__fill_1
XFILLER_0_53_86 VGND VGND VPWR VPWR sky130_fd_sc_hd__fill_2
X_4983_ _2476_ VGND VGND VPWR VPWR _0141_ sky130_fd_sc_hd__clkbuf_1
XTAP_TAPCELL_ROW_38_417 VGND VPWR sky130_fd_sc_hd__tapvpwrvgnd_1
X_5604_ _2421_ reg_file.memory\[25\]\[6\] _2797_ VGND VGND VPWR VPWR _2804_ sky130_fd_sc_hd__mux2_1
XFILLER_0_5_110 VGND VGND VPWR VPWR sky130_fd_sc_hd__fill_2
X_3865_ _1510_ _1513_ VGND VGND VPWR VPWR _1521_ sky130_fd_sc_hd__and2_1
X_3796_ _1450_ _1451_ VGND VGND VPWR VPWR _1452_ sky130_fd_sc_hd__or2_1
X_3934_ _1585_ _1581_ _1583_ VGND VGND VPWR VPWR _1590_ sky130_fd_sc_hd__or3_1
XTAP_TAPCELL_ROW_21_317 VGND VPWR sky130_fd_sc_hd__tapvpwrvgnd_1
X_4417_ _1707_ _1892_ _1887_ _1889_ VGND VGND VPWR VPWR _2053_ sky130_fd_sc_hd__o22a_1
XFILLER_0_75_3 VGND VGND VPWR VPWR sky130_fd_sc_hd__decap_8
X_5397_ _2695_ VGND VGND VPWR VPWR _0336_ sky130_fd_sc_hd__clkbuf_1
X_5535_ _2421_ reg_file.memory\[21\]\[6\] _2760_ VGND VGND VPWR VPWR _2767_ sky130_fd_sc_hd__mux2_1
X_5466_ reg_file.memory\[1\]\[5\] VGND VGND VPWR VPWR _2731_ sky130_fd_sc_hd__clkbuf_1
X_4348_ _1708_ _1987_ VGND VGND VPWR VPWR _1988_ sky130_fd_sc_hd__nor2_1
X_4279_ _1852_ _1856_ _1719_ VGND VGND VPWR VPWR _1922_ sky130_fd_sc_hd__mux2_1
X_6018_ clknet_leaf_18_clk _0253_ VGND VGND VPWR VPWR reg_file.memory\[8\]\[16\] sky130_fd_sc_hd__dfxtp_1
XFILLER_0_83_119 VGND VGND VPWR VPWR sky130_fd_sc_hd__fill_2
XFILLER_0_67_193 VPWR VGND VPWR VGND sky130_ef_sc_hd__decap_12
XFILLER_0_67_160 VGND VGND VPWR VPWR sky130_fd_sc_hd__decap_8
XFILLER_0_55_322 VGND VGND VPWR VPWR sky130_fd_sc_hd__fill_1
X_3650_ _1222_ _1314_ VGND VGND VPWR VPWR _1315_ sky130_fd_sc_hd__xnor2_1
X_5251_ reg_file.memory\[8\]\[30\] _1376_ _2585_ VGND VGND VPWR VPWR _2619_ sky130_fd_sc_hd__mux2_1
X_4202_ _1659_ _1698_ VGND VGND VPWR VPWR _1847_ sky130_fd_sc_hd__nand2_1
X_3581_ reg_file.memory\[4\]\[31\] reg_file.memory\[5\]\[31\] _0595_ VGND VGND VPWR
+ VPWR _1246_ sky130_fd_sc_hd__mux2_1
XFILLER_0_48_42 VGND VGND VPWR VPWR sky130_fd_sc_hd__fill_2
XFILLER_0_2_157 VGND VGND VPWR VPWR sky130_fd_sc_hd__decap_3
X_5320_ _2653_ VGND VGND VPWR VPWR _2654_ sky130_fd_sc_hd__clkbuf_4
XFILLER_0_23_274 VGND VGND VPWR VPWR sky130_fd_sc_hd__decap_3
X_4133_ _1701_ VGND VGND VPWR VPWR _1779_ sky130_fd_sc_hd__clkbuf_4
X_3015_ _0675_ _0679_ _0612_ VGND VGND VPWR VPWR _0680_ sky130_fd_sc_hd__o21a_1
X_4064_ _1675_ VGND VGND VPWR VPWR _1710_ sky130_fd_sc_hd__buf_2
X_5182_ _2581_ VGND VGND VPWR VPWR _0235_ sky130_fd_sc_hd__clkbuf_1
XFILLER_0_48_53 VGND VGND VPWR VPWR sky130_fd_sc_hd__decap_3
XFILLER_0_80_73 VGND VGND VPWR VPWR sky130_fd_sc_hd__decap_4
XFILLER_0_80_51 VGND VGND VPWR VPWR sky130_fd_sc_hd__fill_1
XTAP_TAPCELL_ROW_66_589 VGND VPWR sky130_fd_sc_hd__tapvpwrvgnd_1
XFILLER_0_64_85 VGND VGND VPWR VPWR sky130_fd_sc_hd__fill_2
X_4966_ alu.ALUResult\[27\] VGND VGND VPWR VPWR _2465_ sky130_fd_sc_hd__dlymetal6s2s_1
XFILLER_0_58_171 VPWR VGND VPWR VGND sky130_ef_sc_hd__decap_12
X_5518_ reg_file.memory\[1\]\[31\] VGND VGND VPWR VPWR _2757_ sky130_fd_sc_hd__clkbuf_1
X_4897_ _2418_ VGND VGND VPWR VPWR _0113_ sky130_fd_sc_hd__clkbuf_1
X_3848_ _1500_ _1501_ _1498_ _1503_ VGND VGND VPWR VPWR _1504_ sky130_fd_sc_hd__a2bb2o_1
X_3917_ _1562_ _1566_ VGND VGND VPWR VPWR _1573_ sky130_fd_sc_hd__or2b_1
X_3779_ _1369_ _1434_ _1430_ _1431_ VGND VGND VPWR VPWR _1435_ sky130_fd_sc_hd__o211ai_1
X_5449_ _2722_ VGND VGND VPWR VPWR _0361_ sky130_fd_sc_hd__clkbuf_1
XTAP_TAPCELL_ROW_57_534 VGND VPWR sky130_fd_sc_hd__tapvpwrvgnd_1
XFILLER_0_64_141 VGND VGND VPWR VPWR sky130_fd_sc_hd__decap_8
XFILLER_0_52_325 VGND VGND VPWR VPWR sky130_fd_sc_hd__fill_1
XFILLER_0_9_290 VGND VGND VPWR VPWR sky130_fd_sc_hd__fill_1
XFILLER_0_20_288 VGND VGND VPWR VPWR sky130_fd_sc_hd__decap_8
XFILLER_0_34_99 VGND VGND VPWR VPWR sky130_fd_sc_hd__fill_1
X_4820_ reg_file.memory\[9\]\[5\] VGND VGND VPWR VPWR _2374_ sky130_fd_sc_hd__clkbuf_1
X_4682_ seven_seg_conv.digit_counter\[0\] seven_seg_conv.digit_counter\[1\] seven_seg_conv.digit_counter\[2\]
+ VGND VGND VPWR VPWR _2295_ sky130_fd_sc_hd__a21oi_1
X_3633_ _1046_ _1192_ VGND VGND VPWR VPWR _1298_ sky130_fd_sc_hd__nand2_1
X_4751_ _2336_ VGND VGND VPWR VPWR _0049_ sky130_fd_sc_hd__clkbuf_1
X_3702_ _1357_ VGND VGND VPWR VPWR _1358_ sky130_fd_sc_hd__inv_6
X_5303_ reg_file.memory\[0\]\[24\] VGND VGND VPWR VPWR _2645_ sky130_fd_sc_hd__clkbuf_1
X_3564_ _0755_ _0756_ _1228_ VGND VGND VPWR VPWR _1229_ sky130_fd_sc_hd__o21ba_1
X_3495_ _1158_ _1159_ _0570_ VGND VGND VPWR VPWR _1160_ sky130_fd_sc_hd__mux2_1
X_5165_ _2455_ reg_file.memory\[7\]\[22\] _2570_ VGND VGND VPWR VPWR _2573_ sky130_fd_sc_hd__mux2_1
X_5234_ _2610_ VGND VGND VPWR VPWR _0258_ sky130_fd_sc_hd__clkbuf_1
XFILLER_0_11_244 VGND VGND VPWR VPWR sky130_fd_sc_hd__fill_2
X_4047_ _1682_ _1692_ VGND VGND VPWR VPWR _1693_ sky130_fd_sc_hd__nand2_1
XTAP_TAPCELL_ROW_54_515 VGND VPWR sky130_fd_sc_hd__tapvpwrvgnd_1
X_4116_ _1013_ _1669_ VGND VGND VPWR VPWR _1762_ sky130_fd_sc_hd__nand2_1
X_5096_ _2536_ VGND VGND VPWR VPWR _0194_ sky130_fd_sc_hd__clkbuf_1
X_5998_ clknet_leaf_9_clk _0233_ VGND VGND VPWR VPWR reg_file.memory\[7\]\[28\] sky130_fd_sc_hd__dfxtp_1
XFILLER_0_46_141 VPWR VGND VPWR VGND sky130_ef_sc_hd__decap_12
X_4949_ _2453_ reg_file.memory\[4\]\[21\] _2451_ VGND VGND VPWR VPWR _2454_ sky130_fd_sc_hd__mux2_1
XFILLER_0_61_155 VGND VGND VPWR VPWR sky130_fd_sc_hd__decap_8
XFILLER_0_52_111 VGND VGND VPWR VPWR sky130_fd_sc_hd__fill_1
XFILLER_0_37_196 VGND VGND VPWR VPWR sky130_fd_sc_hd__decap_3
XPHY_EDGE_ROW_4_Left_95 VGND VGND VPWR VPWR sky130_fd_sc_hd__decap_3
XFILLER_0_29_77 VGND VGND VPWR VPWR sky130_fd_sc_hd__fill_1
X_3280_ reg_file.memory\[5\]\[13\] _0944_ _0646_ VGND VGND VPWR VPWR _0945_ sky130_fd_sc_hd__mux2_1
XFILLER_0_29_99 VGND VGND VPWR VPWR sky130_fd_sc_hd__fill_1
X_5921_ clknet_leaf_19_clk _0156_ VGND VGND VPWR VPWR reg_file.memory\[5\]\[15\] sky130_fd_sc_hd__dfxtp_1
XFILLER_0_90_217 VGND VGND VPWR VPWR sky130_fd_sc_hd__fill_1
X_4734_ _2302_ _2324_ _2326_ VGND VGND VPWR VPWR _2327_ sky130_fd_sc_hd__and3_1
X_2995_ PC\[4\] _0549_ PC\[1\] _0547_ VGND VGND VPWR VPWR _0660_ sky130_fd_sc_hd__or4b_2
X_5852_ clknet_leaf_12_clk _0102_ VGND VGND VPWR VPWR reg_file.memory\[9\]\[26\] sky130_fd_sc_hd__dfxtp_1
X_4803_ _1397_ _1399_ _2341_ VGND VGND VPWR VPWR _2366_ sky130_fd_sc_hd__a21oi_1
X_5783_ clk_div.slow_clk _0066_ VGND VGND VPWR VPWR seven_seg_conv.temp\[19\] sky130_fd_sc_hd__dfxtp_1
XFILLER_0_0_67 VPWR VGND VPWR VGND sky130_ef_sc_hd__decap_12
X_4665_ _1263_ _1954_ _2274_ _2280_ VGND VGND VPWR VPWR _0528_ sky130_fd_sc_hd__a211o_1
X_4596_ _0764_ VGND VGND VPWR VPWR _2217_ sky130_fd_sc_hd__inv_2
XFILLER_0_43_166 VGND VGND VPWR VPWR sky130_fd_sc_hd__fill_2
X_3616_ _0998_ _1201_ _1203_ VGND VGND VPWR VPWR _1281_ sky130_fd_sc_hd__nand3_1
X_3547_ _0919_ _1210_ _1211_ VGND VGND VPWR VPWR _1212_ sky130_fd_sc_hd__o21a_1
XFILLER_0_9_43 VGND VGND VPWR VPWR sky130_fd_sc_hd__fill_1
XFILLER_0_9_65 VGND VGND VPWR VPWR sky130_fd_sc_hd__fill_1
X_6266_ clk_div.slow_clk _0501_ VGND VGND VPWR VPWR net3 sky130_fd_sc_hd__dfxtp_1
X_3478_ reg_file.memory\[15\]\[1\] _0609_ _0543_ VGND VGND VPWR VPWR _1143_ sky130_fd_sc_hd__o21a_1
X_6197_ clknet_leaf_1_clk _0432_ VGND VGND VPWR VPWR reg_file.memory\[25\]\[3\] sky130_fd_sc_hd__dfxtp_1
X_5217_ _2601_ VGND VGND VPWR VPWR _0250_ sky130_fd_sc_hd__clkbuf_1
X_5148_ _2438_ reg_file.memory\[7\]\[14\] _2559_ VGND VGND VPWR VPWR _2564_ sky130_fd_sc_hd__mux2_1
X_5079_ _2527_ VGND VGND VPWR VPWR _0186_ sky130_fd_sc_hd__clkbuf_1
XFILLER_0_66_269 VGND VGND VPWR VPWR sky130_fd_sc_hd__fill_2
XFILLER_0_19_185 VGND VGND VPWR VPWR sky130_fd_sc_hd__fill_2
XFILLER_0_57_225 VPWR VGND VPWR VGND sky130_ef_sc_hd__decap_12
X_4381_ _1889_ _1734_ VGND VGND VPWR VPWR _2019_ sky130_fd_sc_hd__nor2_1
XFILLER_0_80_250 VGND VGND VPWR VPWR sky130_fd_sc_hd__fill_2
X_4450_ _1797_ _2078_ _2079_ _2083_ VGND VGND VPWR VPWR _0508_ sky130_fd_sc_hd__a211o_1
X_3401_ reg_file.memory\[4\]\[5\] reg_file.memory\[5\]\[5\] _0590_ VGND VGND VPWR
+ VPWR _1066_ sky130_fd_sc_hd__mux2_1
XFILLER_0_25_111 VGND VGND VPWR VPWR sky130_fd_sc_hd__fill_1
X_6120_ clknet_leaf_13_clk _0355_ VGND VGND VPWR VPWR reg_file.memory\[15\]\[22\]
+ sky130_fd_sc_hd__dfxtp_1
X_3332_ reg_file.memory\[25\]\[10\] _0996_ _0669_ VGND VGND VPWR VPWR _0997_ sky130_fd_sc_hd__mux2_1
X_5002_ _2474_ VGND VGND VPWR VPWR _2486_ sky130_fd_sc_hd__clkbuf_4
XFILLER_0_0_277 VGND VGND VPWR VPWR sky130_fd_sc_hd__decap_3
XFILLER_0_0_222 VGND VGND VPWR VPWR sky130_fd_sc_hd__fill_2
X_6051_ clknet_leaf_18_clk _0286_ VGND VGND VPWR VPWR reg_file.memory\[0\]\[17\] sky130_fd_sc_hd__dfxtp_1
X_3263_ reg_file.memory\[6\]\[14\] reg_file.memory\[7\]\[14\] _0638_ VGND VGND VPWR
+ VPWR _0928_ sky130_fd_sc_hd__mux2_1
X_3194_ _0573_ _0856_ _0858_ _0606_ VGND VGND VPWR VPWR _0859_ sky130_fd_sc_hd__o211a_1
X_5904_ clknet_leaf_9_clk _0139_ VGND VGND VPWR VPWR reg_file.memory\[4\]\[30\] sky130_fd_sc_hd__dfxtp_1
XFILLER_0_48_203 VGND VGND VPWR VPWR sky130_fd_sc_hd__fill_1
X_4717_ clk_div.counter\[7\] clk_div.counter\[6\] _2312_ VGND VGND VPWR VPWR _2316_
+ sky130_fd_sc_hd__and3_1
X_2978_ _0540_ _0628_ VGND VGND VPWR VPWR _0643_ sky130_fd_sc_hd__nor2_1
X_5766_ clk_div.slow_clk _0049_ VGND VGND VPWR VPWR seven_seg_conv.temp\[2\] sky130_fd_sc_hd__dfxtp_1
X_5835_ clknet_leaf_25_clk _0085_ VGND VGND VPWR VPWR reg_file.memory\[9\]\[9\] sky130_fd_sc_hd__dfxtp_1
X_5697_ _2851_ VGND VGND VPWR VPWR _0480_ sky130_fd_sc_hd__clkbuf_1
XFILLER_0_71_294 VGND VGND VPWR VPWR sky130_fd_sc_hd__fill_1
X_4648_ _1963_ _2264_ VGND VGND VPWR VPWR _2265_ sky130_fd_sc_hd__nor2_1
X_4579_ _2157_ _2201_ _1737_ VGND VGND VPWR VPWR _2202_ sky130_fd_sc_hd__mux2_1
XTAP_TAPCELL_ROW_87_713 VGND VPWR sky130_fd_sc_hd__tapvpwrvgnd_1
X_6249_ clknet_leaf_10_clk _0484_ VGND VGND VPWR VPWR reg_file.memory\[2\]\[23\] sky130_fd_sc_hd__dfxtp_1
XFILLER_0_86_309 VGND VGND VPWR VPWR sky130_fd_sc_hd__fill_2
XTAP_TAPCELL_ROW_70_613 VGND VPWR sky130_fd_sc_hd__tapvpwrvgnd_1
XFILLER_0_89_169 VGND VGND VPWR VPWR sky130_fd_sc_hd__decap_4
XFILLER_0_89_158 VGND VGND VPWR VPWR sky130_fd_sc_hd__decap_8
X_3950_ _1598_ _1603_ _1601_ VGND VGND VPWR VPWR _1606_ sky130_fd_sc_hd__a21o_1
XTAP_TAPCELL_ROW_18_301 VGND VPWR sky130_fd_sc_hd__tapvpwrvgnd_1
X_2901_ _0565_ VGND VGND VPWR VPWR _0566_ sky130_fd_sc_hd__clkbuf_4
XFILLER_0_45_217 VGND VGND VPWR VPWR sky130_fd_sc_hd__fill_1
X_5551_ _2775_ VGND VGND VPWR VPWR _0410_ sky130_fd_sc_hd__clkbuf_1
X_5620_ _2812_ VGND VGND VPWR VPWR _0442_ sky130_fd_sc_hd__clkbuf_1
X_3881_ _1535_ _1526_ _1531_ VGND VGND VPWR VPWR _1537_ sky130_fd_sc_hd__a21oi_1
X_4364_ _1889_ _2002_ VGND VGND VPWR VPWR _2003_ sky130_fd_sc_hd__nor2_1
X_4433_ _1658_ _1919_ VGND VGND VPWR VPWR _2068_ sky130_fd_sc_hd__nor2_1
X_4502_ _1735_ _2131_ VGND VGND VPWR VPWR _2132_ sky130_fd_sc_hd__nand2_1
XFILLER_0_13_147 VGND VGND VPWR VPWR sky130_fd_sc_hd__fill_1
X_5482_ reg_file.memory\[1\]\[13\] VGND VGND VPWR VPWR _2739_ sky130_fd_sc_hd__clkbuf_1
X_4295_ _1907_ _1909_ _1937_ VGND VGND VPWR VPWR _0530_ sky130_fd_sc_hd__a21oi_1
X_6034_ clknet_leaf_1_clk _0269_ VGND VGND VPWR VPWR reg_file.memory\[0\]\[0\] sky130_fd_sc_hd__dfxtp_1
X_6103_ clknet_leaf_1_clk _0338_ VGND VGND VPWR VPWR reg_file.memory\[15\]\[5\] sky130_fd_sc_hd__dfxtp_1
X_3246_ reg_file.memory\[21\]\[15\] _0544_ _0625_ _0910_ VGND VGND VPWR VPWR _0911_
+ sky130_fd_sc_hd__o211ai_2
X_3315_ _0977_ _0979_ _0663_ VGND VGND VPWR VPWR _0980_ sky130_fd_sc_hd__mux2_1
XFILLER_0_20_3 VGND VGND VPWR VPWR sky130_fd_sc_hd__fill_1
X_3177_ _0600_ _0841_ VGND VGND VPWR VPWR _0842_ sky130_fd_sc_hd__or2_1
XFILLER_0_83_84 VGND VGND VPWR VPWR sky130_fd_sc_hd__decap_3
XTAP_TAPCELL_ROW_24_337 VGND VPWR sky130_fd_sc_hd__tapvpwrvgnd_1
X_5749_ clknet_leaf_6_clk _0033_ VGND VGND VPWR VPWR clk_div.counter\[4\] sky130_fd_sc_hd__dfxtp_1
X_5818_ _0521_ _0014_ VGND VGND VPWR VPWR alu.ALUResult\[24\] sky130_fd_sc_hd__dlxtn_1
XFILLER_0_44_261 VGND VGND VPWR VPWR sky130_fd_sc_hd__fill_1
XTAP_TAPCELL_ROW_32_381 VGND VPWR sky130_fd_sc_hd__tapvpwrvgnd_1
XFILLER_0_8_141 VGND VGND VPWR VPWR sky130_fd_sc_hd__fill_2
XFILLER_0_12_191 VGND VGND VPWR VPWR sky130_fd_sc_hd__decap_4
XFILLER_0_82_301 VGND VGND VPWR VPWR sky130_fd_sc_hd__fill_1
XFILLER_0_12_58 VGND VGND VPWR VPWR sky130_fd_sc_hd__fill_1
XFILLER_0_2_317 VGND VGND VPWR VPWR sky130_fd_sc_hd__fill_2
X_3031_ _0691_ _0695_ _0612_ VGND VGND VPWR VPWR _0696_ sky130_fd_sc_hd__o21a_1
X_4080_ _0754_ _1671_ VGND VGND VPWR VPWR _1726_ sky130_fd_sc_hd__nand2_1
X_3100_ reg_file.memory\[6\]\[24\] reg_file.memory\[7\]\[24\] _0640_ VGND VGND VPWR
+ VPWR _0765_ sky130_fd_sc_hd__mux2_1
XTAP_TAPCELL_ROW_38_418 VGND VPWR sky130_fd_sc_hd__tapvpwrvgnd_1
XFILLER_0_77_117 VGND VGND VPWR VPWR sky130_fd_sc_hd__fill_1
X_4982_ _2401_ reg_file.memory\[5\]\[0\] _2475_ VGND VGND VPWR VPWR _2476_ sky130_fd_sc_hd__mux2_1
XFILLER_0_53_21 VGND VGND VPWR VPWR sky130_fd_sc_hd__fill_1
X_3933_ _1587_ _1588_ VGND VGND VPWR VPWR _1589_ sky130_fd_sc_hd__or2_1
XFILLER_0_18_206 VGND VGND VPWR VPWR sky130_fd_sc_hd__fill_2
X_5603_ _2803_ VGND VGND VPWR VPWR _0434_ sky130_fd_sc_hd__clkbuf_1
X_5534_ _2766_ VGND VGND VPWR VPWR _0402_ sky130_fd_sc_hd__clkbuf_1
XFILLER_0_5_188 VPWR VGND VPWR VGND sky130_ef_sc_hd__decap_12
X_3864_ _1515_ _1516_ _1517_ _1519_ VGND VGND VPWR VPWR _1520_ sky130_fd_sc_hd__a2bb2o_1
X_3795_ _1448_ _1449_ _1447_ VGND VGND VPWR VPWR _1451_ sky130_fd_sc_hd__a21oi_1
XTAP_TAPCELL_ROW_21_318 VGND VPWR sky130_fd_sc_hd__tapvpwrvgnd_1
X_4347_ _1891_ _1885_ _1704_ VGND VGND VPWR VPWR _1987_ sky130_fd_sc_hd__mux2_1
X_4416_ _1789_ _1880_ _2021_ _2051_ VGND VGND VPWR VPWR _2052_ sky130_fd_sc_hd__a31o_1
X_5396_ _2415_ reg_file.memory\[15\]\[3\] _2691_ VGND VGND VPWR VPWR _2695_ sky130_fd_sc_hd__mux2_1
XFILLER_0_41_297 VGND VGND VPWR VPWR sky130_fd_sc_hd__fill_1
X_5465_ _2730_ VGND VGND VPWR VPWR _0369_ sky130_fd_sc_hd__clkbuf_1
X_4278_ _1813_ _1849_ _1687_ VGND VGND VPWR VPWR _1921_ sky130_fd_sc_hd__mux2_1
X_6017_ clknet_leaf_20_clk _0252_ VGND VGND VPWR VPWR reg_file.memory\[8\]\[15\] sky130_fd_sc_hd__dfxtp_1
X_3229_ reg_file.memory\[6\]\[16\] reg_file.memory\[7\]\[16\] _0638_ VGND VGND VPWR
+ VPWR _0894_ sky130_fd_sc_hd__mux2_1
XFILLER_0_76_150 VGND VGND VPWR VPWR sky130_fd_sc_hd__decap_3
X_3580_ reg_file.memory\[2\]\[31\] _0567_ _0574_ reg_file.memory\[7\]\[31\] _0581_
+ VGND VGND VPWR VPWR _1245_ sky130_fd_sc_hd__o221a_1
X_5250_ _2618_ VGND VGND VPWR VPWR _0266_ sky130_fd_sc_hd__clkbuf_1
X_4201_ _1767_ _1836_ _1844_ _1845_ VGND VGND VPWR VPWR _1846_ sky130_fd_sc_hd__o211a_1
X_5181_ _2471_ reg_file.memory\[7\]\[30\] _2547_ VGND VGND VPWR VPWR _2581_ sky130_fd_sc_hd__mux2_1
X_4132_ _1775_ _1777_ VGND VGND VPWR VPWR _1778_ sky130_fd_sc_hd__and2b_1
X_3014_ _0575_ _0676_ _0678_ _0607_ VGND VGND VPWR VPWR _0679_ sky130_fd_sc_hd__o211a_1
X_4063_ _1259_ _1671_ VGND VGND VPWR VPWR _1709_ sky130_fd_sc_hd__nand2_1
XPHY_EDGE_ROW_79_Left_170 VGND VGND VPWR VPWR sky130_fd_sc_hd__decap_3
XFILLER_0_80_96 VGND VGND VPWR VPWR sky130_fd_sc_hd__fill_1
XFILLER_0_58_183 VGND VGND VPWR VPWR sky130_fd_sc_hd__decap_4
X_4965_ _2464_ VGND VGND VPWR VPWR _0135_ sky130_fd_sc_hd__clkbuf_1
X_4896_ _2417_ reg_file.memory\[4\]\[4\] _2409_ VGND VGND VPWR VPWR _2418_ sky130_fd_sc_hd__mux2_1
X_3916_ _1559_ _1561_ _1567_ _1571_ VGND VGND VPWR VPWR _1572_ sky130_fd_sc_hd__a2bb2o_1
X_5517_ _2756_ VGND VGND VPWR VPWR _0395_ sky130_fd_sc_hd__clkbuf_1
XFILLER_0_61_337 VGND VGND VPWR VPWR sky130_fd_sc_hd__fill_2
X_3847_ _1502_ VGND VGND VPWR VPWR _1503_ sky130_fd_sc_hd__inv_2
X_3778_ _1428_ _1429_ VGND VGND VPWR VPWR _1434_ sky130_fd_sc_hd__xnor2_1
X_5379_ reg_file.memory\[10\]\[28\] alu.ALUResult\[28\] _2676_ VGND VGND VPWR VPWR
+ _2685_ sky130_fd_sc_hd__mux2_1
X_5448_ _2467_ reg_file.memory\[15\]\[28\] _2713_ VGND VGND VPWR VPWR _2722_ sky130_fd_sc_hd__mux2_1
XTAP_TAPCELL_ROW_57_535 VGND VPWR sky130_fd_sc_hd__tapvpwrvgnd_1
XPHY_EDGE_ROW_29_Right_29 VGND VGND VPWR VPWR sky130_fd_sc_hd__decap_3
XFILLER_0_64_197 VGND VGND VPWR VPWR sky130_fd_sc_hd__decap_4
XFILLER_0_52_304 VGND VGND VPWR VPWR sky130_fd_sc_hd__fill_1
XPHY_EDGE_ROW_38_Right_38 VGND VGND VPWR VPWR sky130_fd_sc_hd__decap_3
XPHY_EDGE_ROW_47_Right_47 VGND VGND VPWR VPWR sky130_fd_sc_hd__decap_3
XPHY_EDGE_ROW_56_Right_56 VGND VGND VPWR VPWR sky130_fd_sc_hd__decap_3
XFILLER_0_55_131 VGND VGND VPWR VPWR sky130_fd_sc_hd__decap_8
X_4750_ seven_seg_conv.temp\[2\] _1606_ _2334_ VGND VGND VPWR VPWR _2336_ sky130_fd_sc_hd__mux2_1
XFILLER_0_7_228 VGND VGND VPWR VPWR sky130_fd_sc_hd__fill_1
X_5302_ _2644_ VGND VGND VPWR VPWR _0292_ sky130_fd_sc_hd__clkbuf_1
X_4681_ seven_seg_conv.digit_counter\[2\] seven_seg_conv.digit_counter\[0\] seven_seg_conv.digit_counter\[1\]
+ VGND VGND VPWR VPWR _2294_ sky130_fd_sc_hd__and3_1
XFILLER_0_70_178 VGND VGND VPWR VPWR sky130_fd_sc_hd__fill_2
XFILLER_0_70_156 VGND VGND VPWR VPWR sky130_fd_sc_hd__fill_1
X_3563_ _0774_ _1227_ _0772_ VGND VGND VPWR VPWR _1228_ sky130_fd_sc_hd__o21a_1
XFILLER_0_50_55 VGND VGND VPWR VPWR sky130_fd_sc_hd__fill_1
X_3632_ _1290_ _1291_ _1294_ _1296_ VGND VGND VPWR VPWR _1297_ sky130_fd_sc_hd__or4_1
XFILLER_0_43_337 VGND VGND VPWR VPWR sky130_fd_sc_hd__fill_2
X_3701_ seven_seg_conv.temp\[9\] alu.ALUResult\[9\] _1347_ VGND VGND VPWR VPWR _1357_
+ sky130_fd_sc_hd__mux2_1
XFILLER_0_11_223 VGND VGND VPWR VPWR sky130_fd_sc_hd__fill_1
XFILLER_0_75_52 VGND VGND VPWR VPWR sky130_fd_sc_hd__decap_4
X_4115_ _1165_ _1760_ VGND VGND VPWR VPWR _1761_ sky130_fd_sc_hd__or2_1
XPHY_EDGE_ROW_65_Right_65 VGND VGND VPWR VPWR sky130_fd_sc_hd__decap_3
X_3494_ reg_file.memory\[0\]\[0\] reg_file.memory\[1\]\[0\] _0589_ VGND VGND VPWR
+ VPWR _1159_ sky130_fd_sc_hd__mux2_1
X_5233_ reg_file.memory\[8\]\[21\] alu.ALUResult\[21\] _2608_ VGND VGND VPWR VPWR
+ _2610_ sky130_fd_sc_hd__mux2_1
X_5164_ _2572_ VGND VGND VPWR VPWR _0226_ sky130_fd_sc_hd__clkbuf_1
XFILLER_0_75_96 VPWR VGND VPWR VGND sky130_ef_sc_hd__decap_12
X_4046_ _0869_ _1671_ VGND VGND VPWR VPWR _1692_ sky130_fd_sc_hd__nand2_1
XTAP_TAPCELL_ROW_54_516 VGND VPWR sky130_fd_sc_hd__tapvpwrvgnd_1
X_5095_ _2453_ reg_file.memory\[6\]\[21\] _2534_ VGND VGND VPWR VPWR _2536_ sky130_fd_sc_hd__mux2_1
XPHY_EDGE_ROW_74_Right_74 VGND VGND VPWR VPWR sky130_fd_sc_hd__decap_3
X_4879_ _2402_ _2404_ VGND VGND VPWR VPWR _2405_ sky130_fd_sc_hd__nand2_1
XTAP_TAPCELL_ROW_62_560 VGND VPWR sky130_fd_sc_hd__tapvpwrvgnd_1
X_5997_ clknet_leaf_12_clk _0232_ VGND VGND VPWR VPWR reg_file.memory\[7\]\[27\] sky130_fd_sc_hd__dfxtp_1
XFILLER_0_46_164 VGND VGND VPWR VPWR sky130_fd_sc_hd__decap_8
XFILLER_0_46_153 VGND VGND VPWR VPWR sky130_fd_sc_hd__decap_6
XFILLER_0_46_131 VGND VGND VPWR VPWR sky130_fd_sc_hd__decap_8
X_4948_ alu.ALUResult\[21\] VGND VGND VPWR VPWR _2453_ sky130_fd_sc_hd__buf_1
XPHY_EDGE_ROW_83_Right_83 VGND VGND VPWR VPWR sky130_fd_sc_hd__decap_3
XFILLER_0_69_223 VGND VGND VPWR VPWR sky130_fd_sc_hd__fill_1
XFILLER_0_29_109 VGND VGND VPWR VPWR sky130_fd_sc_hd__decap_3
XFILLER_0_52_145 VGND VGND VPWR VPWR sky130_fd_sc_hd__fill_2
XFILLER_0_20_25 VGND VGND VPWR VPWR sky130_fd_sc_hd__decap_3
XFILLER_0_45_55 VGND VGND VPWR VPWR sky130_fd_sc_hd__fill_1
X_5920_ clknet_leaf_20_clk _0155_ VGND VGND VPWR VPWR reg_file.memory\[5\]\[14\] sky130_fd_sc_hd__dfxtp_1
X_4733_ _2325_ VGND VGND VPWR VPWR _2326_ sky130_fd_sc_hd__inv_2
X_2994_ _0658_ reg_file.memory\[10\]\[30\] _0650_ VGND VGND VPWR VPWR _0659_ sky130_fd_sc_hd__mux2_1
X_5851_ clknet_leaf_12_clk _0101_ VGND VGND VPWR VPWR reg_file.memory\[9\]\[25\] sky130_fd_sc_hd__dfxtp_1
XFILLER_0_28_197 VGND VGND VPWR VPWR sky130_fd_sc_hd__decap_4
X_5782_ clk_div.slow_clk _0065_ VGND VGND VPWR VPWR seven_seg_conv.temp\[18\] sky130_fd_sc_hd__dfxtp_1
XFILLER_0_0_57 VGND VGND VPWR VPWR sky130_fd_sc_hd__decap_6
XFILLER_0_0_79 VGND VGND VPWR VPWR sky130_fd_sc_hd__decap_4
XTAP_TAPCELL_ROW_16_284 VGND VPWR sky130_fd_sc_hd__tapvpwrvgnd_1
X_4802_ _2365_ VGND VGND VPWR VPWR _0071_ sky130_fd_sc_hd__clkbuf_1
X_6265_ clk_div.slow_clk _0500_ VGND VGND VPWR VPWR net4 sky130_fd_sc_hd__dfxtp_1
X_4664_ _1976_ _2105_ _2279_ _2041_ VGND VGND VPWR VPWR _2280_ sky130_fd_sc_hd__o211a_1
X_4595_ _1270_ _1994_ _2209_ _2216_ VGND VGND VPWR VPWR _0521_ sky130_fd_sc_hd__a211o_1
X_3615_ _1206_ _1279_ VGND VGND VPWR VPWR _1280_ sky130_fd_sc_hd__or2_1
X_3546_ _0911_ _0918_ VGND VGND VPWR VPWR _1211_ sky130_fd_sc_hd__nand2_1
X_3477_ _0604_ _1140_ _1141_ _0551_ VGND VGND VPWR VPWR _1142_ sky130_fd_sc_hd__a211o_1
X_6196_ clknet_leaf_4_clk _0431_ VGND VGND VPWR VPWR reg_file.memory\[25\]\[2\] sky130_fd_sc_hd__dfxtp_1
X_5147_ _2563_ VGND VGND VPWR VPWR _0218_ sky130_fd_sc_hd__clkbuf_1
X_5216_ reg_file.memory\[8\]\[13\] alu.ALUResult\[13\] _2597_ VGND VGND VPWR VPWR
+ _2601_ sky130_fd_sc_hd__mux2_1
X_5078_ _2436_ reg_file.memory\[6\]\[13\] _2523_ VGND VGND VPWR VPWR _2527_ sky130_fd_sc_hd__mux2_1
X_4029_ _1674_ VGND VGND VPWR VPWR _1675_ sky130_fd_sc_hd__buf_2
XFILLER_0_81_207 VGND VGND VPWR VPWR sky130_fd_sc_hd__fill_1
XFILLER_0_22_307 VGND VGND VPWR VPWR sky130_fd_sc_hd__fill_1
XTAP_TAPCELL_ROW_7_230 VGND VPWR sky130_fd_sc_hd__tapvpwrvgnd_1
XFILLER_0_65_270 VGND VGND VPWR VPWR sky130_fd_sc_hd__decap_6
XFILLER_0_57_237 VGND VGND VPWR VPWR sky130_fd_sc_hd__decap_3
XFILLER_0_15_69 VGND VGND VPWR VPWR sky130_fd_sc_hd__fill_1
X_4380_ _2015_ _1194_ _1997_ _2017_ VGND VGND VPWR VPWR _2018_ sky130_fd_sc_hd__o31a_1
X_3400_ reg_file.memory\[2\]\[5\] _0566_ _0571_ reg_file.memory\[7\]\[5\] _0579_ VGND
+ VGND VPWR VPWR _1065_ sky130_fd_sc_hd__o221a_1
X_3331_ _0993_ _0995_ _0663_ VGND VGND VPWR VPWR _0996_ sky130_fd_sc_hd__mux2_1
XFILLER_0_56_76 VGND VGND VPWR VPWR sky130_fd_sc_hd__fill_2
X_3262_ reg_file.memory\[21\]\[14\] _0544_ _0625_ _0926_ VGND VGND VPWR VPWR _0927_
+ sky130_fd_sc_hd__o211ai_4
X_5001_ _2485_ VGND VGND VPWR VPWR _0150_ sky130_fd_sc_hd__clkbuf_1
X_6050_ clknet_leaf_20_clk _0285_ VGND VGND VPWR VPWR reg_file.memory\[0\]\[16\] sky130_fd_sc_hd__dfxtp_1
X_3193_ _0599_ _0857_ VGND VGND VPWR VPWR _0858_ sky130_fd_sc_hd__or2_1
X_5903_ clknet_leaf_10_clk _0138_ VGND VGND VPWR VPWR reg_file.memory\[4\]\[29\] sky130_fd_sc_hd__dfxtp_1
XFILLER_0_48_248 VGND VGND VPWR VPWR sky130_fd_sc_hd__decap_4
XFILLER_0_48_237 VGND VGND VPWR VPWR sky130_fd_sc_hd__decap_4
XFILLER_0_8_312 VGND VGND VPWR VPWR sky130_fd_sc_hd__fill_2
X_5834_ clknet_leaf_25_clk _0084_ VGND VGND VPWR VPWR reg_file.memory\[9\]\[8\] sky130_fd_sc_hd__dfxtp_1
X_4716_ clk_div.counter\[5\] clk_div.counter\[6\] _2308_ clk_div.counter\[7\] VGND
+ VGND VPWR VPWR _2315_ sky130_fd_sc_hd__a31o_1
X_4647_ _1682_ _1716_ _1825_ VGND VGND VPWR VPWR _2264_ sky130_fd_sc_hd__o21a_1
X_2977_ reg_file.memory\[6\]\[30\] reg_file.memory\[7\]\[30\] _0641_ VGND VGND VPWR
+ VPWR _0642_ sky130_fd_sc_hd__mux2_1
XFILLER_0_63_229 VGND VGND VPWR VPWR sky130_fd_sc_hd__fill_1
XFILLER_0_63_207 VPWR VGND VPWR VGND sky130_ef_sc_hd__decap_12
X_5765_ clk_div.slow_clk _0048_ VGND VGND VPWR VPWR seven_seg_conv.temp\[1\] sky130_fd_sc_hd__dfxtp_1
XPHY_EDGE_ROW_15_Left_106 VGND VGND VPWR VPWR sky130_fd_sc_hd__decap_3
X_5696_ reg_file.memory\[2\]\[19\] VGND VGND VPWR VPWR _2851_ sky130_fd_sc_hd__clkbuf_1
X_4578_ _2176_ _2200_ _1819_ VGND VGND VPWR VPWR _2201_ sky130_fd_sc_hd__mux2_1
X_6248_ clknet_leaf_12_clk _0483_ VGND VGND VPWR VPWR reg_file.memory\[2\]\[22\] sky130_fd_sc_hd__dfxtp_1
X_3529_ _1030_ _1193_ VGND VGND VPWR VPWR _1194_ sky130_fd_sc_hd__nand2_1
XFILLER_0_31_137 VGND VGND VPWR VPWR sky130_fd_sc_hd__fill_2
XTAP_TAPCELL_ROW_87_714 VGND VPWR sky130_fd_sc_hd__tapvpwrvgnd_1
X_6179_ clknet_leaf_22_clk _0414_ VGND VGND VPWR VPWR reg_file.memory\[21\]\[17\]
+ sky130_fd_sc_hd__dfxtp_1
XPHY_EDGE_ROW_24_Left_115 VGND VGND VPWR VPWR sky130_fd_sc_hd__decap_3
XPHY_EDGE_ROW_33_Left_124 VGND VGND VPWR VPWR sky130_fd_sc_hd__decap_3
XPHY_EDGE_ROW_42_Left_133 VGND VGND VPWR VPWR sky130_fd_sc_hd__decap_3
XFILLER_0_26_24 VGND VGND VPWR VPWR sky130_fd_sc_hd__fill_1
X_2900_ _0538_ _0557_ _0564_ VGND VGND VPWR VPWR _0565_ sky130_fd_sc_hd__o21ai_2
X_4501_ _2024_ _2060_ _2128_ _2064_ _2130_ VGND VGND VPWR VPWR _2131_ sky130_fd_sc_hd__o221a_1
XFILLER_0_53_284 VGND VGND VPWR VPWR sky130_fd_sc_hd__decap_4
XPHY_EDGE_ROW_51_Left_142 VGND VGND VPWR VPWR sky130_fd_sc_hd__decap_3
X_5550_ _2436_ reg_file.memory\[21\]\[13\] _2771_ VGND VGND VPWR VPWR _2775_ sky130_fd_sc_hd__mux2_1
X_3880_ _1532_ _1534_ _1535_ VGND VGND VPWR VPWR _1536_ sky130_fd_sc_hd__mux2_1
XFILLER_0_5_337 VGND VGND VPWR VPWR sky130_fd_sc_hd__fill_1
X_5481_ _2738_ VGND VGND VPWR VPWR _0377_ sky130_fd_sc_hd__clkbuf_1
X_4363_ _1912_ _1918_ _1767_ VGND VGND VPWR VPWR _2002_ sky130_fd_sc_hd__mux2_1
XPHY_EDGE_ROW_60_Left_151 VGND VGND VPWR VPWR sky130_fd_sc_hd__decap_3
X_4294_ _1900_ _1910_ _1936_ _1902_ VGND VGND VPWR VPWR _1937_ sky130_fd_sc_hd__o211a_1
X_4432_ _1744_ _2065_ _2066_ VGND VGND VPWR VPWR _2067_ sky130_fd_sc_hd__and3b_1
X_6102_ clknet_leaf_1_clk _0337_ VGND VGND VPWR VPWR reg_file.memory\[15\]\[4\] sky130_fd_sc_hd__dfxtp_1
X_3314_ _0978_ reg_file.memory\[10\]\[11\] _0646_ VGND VGND VPWR VPWR _0979_ sky130_fd_sc_hd__mux2_1
X_6033_ clknet_leaf_8_clk _0268_ VGND VGND VPWR VPWR reg_file.memory\[8\]\[31\] sky130_fd_sc_hd__dfxtp_1
XTAP_TAPCELL_ROW_49_482 VGND VPWR sky130_fd_sc_hd__tapvpwrvgnd_1
X_3245_ reg_file.memory\[15\]\[15\] _0553_ _0617_ _0909_ VGND VGND VPWR VPWR _0910_
+ sky130_fd_sc_hd__a211o_1
XFILLER_0_13_3 VGND VGND VPWR VPWR sky130_fd_sc_hd__fill_1
X_3176_ reg_file.memory\[0\]\[19\] reg_file.memory\[1\]\[19\] _0593_ VGND VGND VPWR
+ VPWR _0841_ sky130_fd_sc_hd__mux2_1
XFILLER_0_76_343 VGND VGND VPWR VPWR sky130_fd_sc_hd__fill_1
X_5817_ _0520_ _0014_ VGND VGND VPWR VPWR alu.ALUResult\[23\] sky130_fd_sc_hd__dlxtn_2
XFILLER_0_36_229 VGND VGND VPWR VPWR sky130_fd_sc_hd__fill_1
XFILLER_0_36_218 VGND VGND VPWR VPWR sky130_fd_sc_hd__decap_3
X_5748_ clknet_leaf_6_clk _0032_ VGND VGND VPWR VPWR clk_div.counter\[3\] sky130_fd_sc_hd__dfxtp_1
XTAP_TAPCELL_ROW_32_382 VGND VPWR sky130_fd_sc_hd__tapvpwrvgnd_1
X_5679_ _2842_ VGND VGND VPWR VPWR _0471_ sky130_fd_sc_hd__clkbuf_1
XFILLER_0_79_192 VGND VGND VPWR VPWR sky130_fd_sc_hd__decap_6
XFILLER_0_79_181 VGND VGND VPWR VPWR sky130_fd_sc_hd__decap_6
X_3030_ _0575_ _0692_ _0694_ _0607_ VGND VGND VPWR VPWR _0695_ sky130_fd_sc_hd__o211a_1
XTAP_TAPCELL_ROW_38_419 VGND VPWR sky130_fd_sc_hd__tapvpwrvgnd_1
XFILLER_0_73_313 VGND VGND VPWR VPWR sky130_fd_sc_hd__fill_1
X_4981_ _2474_ VGND VGND VPWR VPWR _2475_ sky130_fd_sc_hd__buf_4
X_3863_ _1361_ _1514_ _1518_ VGND VGND VPWR VPWR _1519_ sky130_fd_sc_hd__o21ai_1
X_3932_ _1586_ _1579_ _1584_ VGND VGND VPWR VPWR _1588_ sky130_fd_sc_hd__a21oi_1
X_5602_ _2419_ reg_file.memory\[25\]\[5\] _2797_ VGND VGND VPWR VPWR _2803_ sky130_fd_sc_hd__mux2_1
X_5533_ _2419_ reg_file.memory\[21\]\[5\] _2760_ VGND VGND VPWR VPWR _2766_ sky130_fd_sc_hd__mux2_1
XFILLER_0_41_210 VGND VGND VPWR VPWR sky130_fd_sc_hd__decap_8
X_5464_ reg_file.memory\[1\]\[4\] VGND VGND VPWR VPWR _2730_ sky130_fd_sc_hd__clkbuf_1
XFILLER_0_5_178 VGND VGND VPWR VPWR sky130_fd_sc_hd__decap_3
X_3794_ _1447_ _1448_ _1449_ VGND VGND VPWR VPWR _1450_ sky130_fd_sc_hd__and3_1
XTAP_TAPCELL_ROW_21_319 VGND VPWR sky130_fd_sc_hd__tapvpwrvgnd_1
XFILLER_0_78_85 VPWR VGND VPWR VGND sky130_ef_sc_hd__decap_12
X_4277_ _1889_ _1914_ _1919_ _1707_ VGND VGND VPWR VPWR _1920_ sky130_fd_sc_hd__o22a_1
X_4346_ _1940_ _1985_ VGND VGND VPWR VPWR _1986_ sky130_fd_sc_hd__nor2_1
X_5395_ _2694_ VGND VGND VPWR VPWR _0335_ sky130_fd_sc_hd__clkbuf_1
X_4415_ _1940_ _2050_ VGND VGND VPWR VPWR _2051_ sky130_fd_sc_hd__nor2_1
XFILLER_0_1_340 VPWR VGND VPWR VGND sky130_ef_sc_hd__decap_12
XFILLER_0_68_129 VGND VGND VPWR VPWR sky130_fd_sc_hd__decap_8
X_3159_ reg_file.memory\[4\]\[20\] reg_file.memory\[5\]\[20\] _0593_ VGND VGND VPWR
+ VPWR _0824_ sky130_fd_sc_hd__mux2_1
X_3228_ reg_file.memory\[21\]\[16\] _0545_ _0625_ _0892_ VGND VGND VPWR VPWR _0893_
+ sky130_fd_sc_hd__o211ai_2
X_6016_ clknet_leaf_20_clk _0251_ VGND VGND VPWR VPWR reg_file.memory\[8\]\[14\] sky130_fd_sc_hd__dfxtp_1
XFILLER_0_64_335 VGND VGND VPWR VPWR sky130_fd_sc_hd__fill_2
XFILLER_0_2_3 VGND VGND VPWR VPWR sky130_fd_sc_hd__decap_6
XFILLER_0_55_335 VGND VGND VPWR VPWR sky130_fd_sc_hd__fill_1
XFILLER_0_55_313 VGND VGND VPWR VPWR sky130_fd_sc_hd__fill_1
Xclkbuf_leaf_25_clk clknet_1_0__leaf_clk VGND VGND VPWR VPWR clknet_leaf_25_clk sky130_fd_sc_hd__clkbuf_8
XFILLER_0_23_47 VGND VGND VPWR VPWR sky130_fd_sc_hd__decap_4
X_5180_ _2580_ VGND VGND VPWR VPWR _0234_ sky130_fd_sc_hd__clkbuf_1
X_4200_ _1107_ _1656_ VGND VGND VPWR VPWR _1845_ sky130_fd_sc_hd__nor2_2
X_4131_ _1674_ _1776_ VGND VGND VPWR VPWR _1777_ sky130_fd_sc_hd__or2_1
X_4062_ _1707_ VGND VGND VPWR VPWR _1708_ sky130_fd_sc_hd__clkbuf_4
X_3013_ _0601_ _0677_ VGND VGND VPWR VPWR _0678_ sky130_fd_sc_hd__or2_1
XFILLER_0_3_68 VGND VGND VPWR VPWR sky130_fd_sc_hd__fill_2
XFILLER_0_3_57 VGND VGND VPWR VPWR sky130_fd_sc_hd__fill_2
Xclkbuf_leaf_16_clk clknet_1_0__leaf_clk VGND VGND VPWR VPWR clknet_leaf_16_clk sky130_fd_sc_hd__clkbuf_8
X_4964_ _2463_ reg_file.memory\[4\]\[26\] _2451_ VGND VGND VPWR VPWR _2464_ sky130_fd_sc_hd__mux2_1
X_4895_ alu.ALUResult\[4\] VGND VGND VPWR VPWR _2417_ sky130_fd_sc_hd__buf_1
X_3846_ seven_seg_conv.temp\[14\] alu.ALUResult\[14\] _1347_ VGND VGND VPWR VPWR _1502_
+ sky130_fd_sc_hd__mux2_2
X_3915_ _1356_ VGND VGND VPWR VPWR _1571_ sky130_fd_sc_hd__inv_2
XFILLER_0_89_40 VGND VGND VPWR VPWR sky130_fd_sc_hd__fill_1
XFILLER_0_80_3 VGND VGND VPWR VPWR sky130_fd_sc_hd__fill_2
X_5516_ reg_file.memory\[1\]\[30\] VGND VGND VPWR VPWR _2756_ sky130_fd_sc_hd__clkbuf_1
X_5447_ _2721_ VGND VGND VPWR VPWR _0360_ sky130_fd_sc_hd__clkbuf_1
X_3777_ _1369_ _1426_ _1432_ VGND VGND VPWR VPWR _1433_ sky130_fd_sc_hd__and3_1
X_5378_ _2684_ VGND VGND VPWR VPWR _0328_ sky130_fd_sc_hd__clkbuf_1
X_4329_ _1867_ _1969_ _1733_ VGND VGND VPWR VPWR _1970_ sky130_fd_sc_hd__mux2_1
XTAP_TAPCELL_ROW_65_580 VGND VPWR sky130_fd_sc_hd__tapvpwrvgnd_1
XFILLER_0_64_132 VGND VGND VPWR VPWR sky130_fd_sc_hd__decap_8
XFILLER_0_37_346 VGND VGND VPWR VPWR sky130_fd_sc_hd__fill_2
X_4680_ _2291_ _2293_ VGND VGND VPWR VPWR _0021_ sky130_fd_sc_hd__nand2_1
XFILLER_0_87_279 VGND VGND VPWR VPWR sky130_fd_sc_hd__fill_1
XFILLER_0_55_110 VGND VGND VPWR VPWR sky130_fd_sc_hd__fill_2
XFILLER_0_34_57 VGND VGND VPWR VPWR sky130_fd_sc_hd__fill_2
XFILLER_0_28_324 VGND VGND VPWR VPWR sky130_fd_sc_hd__fill_2
XFILLER_0_28_313 VGND VGND VPWR VPWR sky130_fd_sc_hd__fill_1
X_3700_ alu.ALUResult\[7\] seven_seg_conv.temp\[7\] _1352_ VGND VGND VPWR VPWR _1356_
+ sky130_fd_sc_hd__mux2_1
X_5301_ reg_file.memory\[0\]\[23\] VGND VGND VPWR VPWR _2644_ sky130_fd_sc_hd__clkbuf_1
X_3562_ _0790_ _1225_ _1226_ VGND VGND VPWR VPWR _1227_ sky130_fd_sc_hd__o21a_1
X_3493_ reg_file.memory\[4\]\[0\] reg_file.memory\[5\]\[0\] _0589_ VGND VGND VPWR
+ VPWR _1158_ sky130_fd_sc_hd__mux2_1
X_3631_ _1189_ _1295_ VGND VGND VPWR VPWR _1296_ sky130_fd_sc_hd__and2_1
XFILLER_0_11_213 VGND VGND VPWR VPWR sky130_fd_sc_hd__decap_3
Xclkbuf_leaf_5_clk clknet_1_1__leaf_clk VGND VGND VPWR VPWR clknet_leaf_5_clk sky130_fd_sc_hd__clkbuf_8
X_4114_ _1029_ _1669_ VGND VGND VPWR VPWR _1760_ sky130_fd_sc_hd__nand2_1
X_5163_ _2453_ reg_file.memory\[7\]\[21\] _2570_ VGND VGND VPWR VPWR _2572_ sky130_fd_sc_hd__mux2_1
X_5094_ _2535_ VGND VGND VPWR VPWR _0193_ sky130_fd_sc_hd__clkbuf_1
X_5232_ _2609_ VGND VGND VPWR VPWR _0257_ sky130_fd_sc_hd__clkbuf_1
X_4045_ _1689_ _1690_ VGND VGND VPWR VPWR _1691_ sky130_fd_sc_hd__nand2_1
XTAP_TAPCELL_ROW_54_517 VGND VPWR sky130_fd_sc_hd__tapvpwrvgnd_1
X_5996_ clknet_leaf_16_clk _0231_ VGND VGND VPWR VPWR reg_file.memory\[7\]\[26\] sky130_fd_sc_hd__dfxtp_1
X_4878_ _0576_ _0559_ _2403_ _0643_ _0584_ VGND VGND VPWR VPWR _2404_ sky130_fd_sc_hd__o32a_2
XTAP_TAPCELL_ROW_62_561 VGND VPWR sky130_fd_sc_hd__tapvpwrvgnd_1
XFILLER_0_46_176 VGND VGND VPWR VPWR sky130_fd_sc_hd__fill_2
X_4947_ _2452_ VGND VGND VPWR VPWR _0129_ sky130_fd_sc_hd__clkbuf_1
X_3829_ _1480_ VGND VGND VPWR VPWR _1485_ sky130_fd_sc_hd__inv_2
XFILLER_0_6_251 VGND VGND VPWR VPWR sky130_fd_sc_hd__fill_1
XFILLER_0_6_284 VGND VGND VPWR VPWR sky130_fd_sc_hd__fill_2
XFILLER_0_37_110 VGND VGND VPWR VPWR sky130_fd_sc_hd__fill_2
XFILLER_0_75_205 VGND VGND VPWR VPWR sky130_fd_sc_hd__decap_8
X_5850_ clknet_leaf_12_clk _0100_ VGND VGND VPWR VPWR reg_file.memory\[9\]\[24\] sky130_fd_sc_hd__dfxtp_1
XFILLER_0_45_34 VGND VGND VPWR VPWR sky130_fd_sc_hd__fill_2
X_4732_ clk_div.counter\[13\] clk_div.counter\[12\] _2321_ VGND VGND VPWR VPWR _2325_
+ sky130_fd_sc_hd__and3_1
X_2993_ reg_file.memory\[8\]\[30\] reg_file.memory\[9\]\[30\] _0641_ VGND VGND VPWR
+ VPWR _0658_ sky130_fd_sc_hd__mux2_1
X_4663_ _2071_ _2193_ _2278_ VGND VGND VPWR VPWR _2279_ sky130_fd_sc_hd__o21bai_1
X_3614_ _0982_ _1204_ _1205_ VGND VGND VPWR VPWR _1279_ sky130_fd_sc_hd__and3_1
XFILLER_0_43_146 VGND VGND VPWR VPWR sky130_fd_sc_hd__fill_1
X_5781_ clk_div.slow_clk _0064_ VGND VGND VPWR VPWR seven_seg_conv.temp\[17\] sky130_fd_sc_hd__dfxtp_1
XTAP_TAPCELL_ROW_16_285 VGND VPWR sky130_fd_sc_hd__tapvpwrvgnd_1
X_4801_ seven_seg_conv.temp\[24\] _1408_ _1635_ VGND VGND VPWR VPWR _2365_ sky130_fd_sc_hd__mux2_1
X_6264_ clk_div.slow_clk _0499_ VGND VGND VPWR VPWR net5 sky130_fd_sc_hd__dfxtp_1
X_3476_ reg_file.memory\[2\]\[1\] _0565_ _0570_ reg_file.memory\[7\]\[1\] _0578_ VGND
+ VGND VPWR VPWR _1141_ sky130_fd_sc_hd__o221a_1
X_4594_ _1976_ _2026_ _2215_ _2041_ VGND VGND VPWR VPWR _2216_ sky130_fd_sc_hd__o211a_1
X_3545_ _0927_ _0934_ _0935_ _1209_ VGND VGND VPWR VPWR _1210_ sky130_fd_sc_hd__o2bb2a_1
XFILLER_0_24_360 VGND VGND VPWR VPWR sky130_fd_sc_hd__fill_1
XFILLER_0_3_232 VGND VGND VPWR VPWR sky130_fd_sc_hd__fill_1
X_5215_ _2600_ VGND VGND VPWR VPWR _0249_ sky130_fd_sc_hd__clkbuf_1
X_6195_ clknet_leaf_5_clk _0430_ VGND VGND VPWR VPWR reg_file.memory\[25\]\[1\] sky130_fd_sc_hd__dfxtp_1
X_4028_ _0590_ _0624_ _1164_ VGND VGND VPWR VPWR _1674_ sky130_fd_sc_hd__o21ai_2
XFILLER_0_43_3 VGND VGND VPWR VPWR sky130_fd_sc_hd__fill_2
X_5077_ _2526_ VGND VGND VPWR VPWR _0185_ sky130_fd_sc_hd__clkbuf_1
X_5146_ _2436_ reg_file.memory\[7\]\[13\] _2559_ VGND VGND VPWR VPWR _2563_ sky130_fd_sc_hd__mux2_1
X_5979_ clknet_leaf_23_clk _0214_ VGND VGND VPWR VPWR reg_file.memory\[7\]\[9\] sky130_fd_sc_hd__dfxtp_1
XFILLER_0_19_165 VGND VGND VPWR VPWR sky130_fd_sc_hd__decap_3
XFILLER_0_34_135 VGND VGND VPWR VPWR sky130_fd_sc_hd__fill_2
XTAP_TAPCELL_ROW_7_231 VGND VPWR sky130_fd_sc_hd__tapvpwrvgnd_1
XFILLER_0_57_205 VPWR VGND VPWR VGND sky130_ef_sc_hd__decap_12
XFILLER_0_31_36 VGND VGND VPWR VPWR sky130_fd_sc_hd__fill_2
XFILLER_0_31_25 VGND VGND VPWR VPWR sky130_fd_sc_hd__fill_1
XFILLER_0_25_113 VGND VGND VPWR VPWR sky130_fd_sc_hd__fill_1
XTAP_TAPCELL_ROW_13_266 VGND VPWR sky130_fd_sc_hd__tapvpwrvgnd_1
XFILLER_0_40_138 VGND VGND VPWR VPWR sky130_fd_sc_hd__fill_2
XFILLER_0_0_202 VGND VGND VPWR VPWR sky130_fd_sc_hd__decap_4
X_3330_ _0994_ reg_file.memory\[10\]\[10\] _0646_ VGND VGND VPWR VPWR _0995_ sky130_fd_sc_hd__mux2_1
XFILLER_0_21_363 VGND VGND VPWR VPWR sky130_fd_sc_hd__fill_1
X_3261_ reg_file.memory\[15\]\[14\] _0553_ _0617_ _0925_ VGND VGND VPWR VPWR _0926_
+ sky130_fd_sc_hd__a211o_1
X_3192_ reg_file.memory\[0\]\[18\] reg_file.memory\[1\]\[18\] _0593_ VGND VGND VPWR
+ VPWR _0857_ sky130_fd_sc_hd__mux2_1
X_5000_ _2427_ reg_file.memory\[5\]\[9\] _2475_ VGND VGND VPWR VPWR _2485_ sky130_fd_sc_hd__mux2_1
X_5902_ clknet_leaf_10_clk _0137_ VGND VGND VPWR VPWR reg_file.memory\[4\]\[28\] sky130_fd_sc_hd__dfxtp_1
XFILLER_0_72_43 VGND VGND VPWR VPWR sky130_fd_sc_hd__fill_2
XFILLER_0_63_219 VGND VGND VPWR VPWR sky130_fd_sc_hd__decap_4
X_5833_ clknet_leaf_26_clk _0083_ VGND VGND VPWR VPWR reg_file.memory\[9\]\[7\] sky130_fd_sc_hd__dfxtp_1
X_4715_ clk_div.counter\[6\] _2312_ _2314_ VGND VGND VPWR VPWR _0035_ sky130_fd_sc_hd__a21oi_1
X_2976_ _0640_ VGND VGND VPWR VPWR _0641_ sky130_fd_sc_hd__clkbuf_4
X_4577_ _1802_ _1804_ VGND VGND VPWR VPWR _2200_ sky130_fd_sc_hd__nand2_1
X_4646_ _1800_ _2087_ VGND VGND VPWR VPWR _2263_ sky130_fd_sc_hd__or2_1
X_5764_ clk_div.slow_clk _0047_ VGND VGND VPWR VPWR seven_seg_conv.temp\[0\] sky130_fd_sc_hd__dfxtp_1
X_5695_ _2850_ VGND VGND VPWR VPWR _0479_ sky130_fd_sc_hd__clkbuf_1
XTAP_TAPCELL_ROW_87_715 VGND VPWR sky130_fd_sc_hd__tapvpwrvgnd_1
X_3459_ _0578_ _1122_ _1123_ _0609_ VGND VGND VPWR VPWR _1124_ sky130_fd_sc_hd__o211a_1
X_6247_ clknet_leaf_16_clk _0482_ VGND VGND VPWR VPWR reg_file.memory\[2\]\[21\] sky130_fd_sc_hd__dfxtp_1
X_3528_ _1022_ _1029_ VGND VGND VPWR VPWR _1193_ sky130_fd_sc_hd__or2_1
X_6178_ clknet_leaf_22_clk _0413_ VGND VGND VPWR VPWR reg_file.memory\[21\]\[16\]
+ sky130_fd_sc_hd__dfxtp_1
XTAP_TAPCELL_ROW_4_212 VGND VPWR sky130_fd_sc_hd__tapvpwrvgnd_1
XFILLER_0_12_363 VGND VGND VPWR VPWR sky130_fd_sc_hd__fill_1
X_5129_ _2419_ reg_file.memory\[7\]\[5\] _2548_ VGND VGND VPWR VPWR _2554_ sky130_fd_sc_hd__mux2_1
XFILLER_0_22_138 VGND VGND VPWR VPWR sky130_fd_sc_hd__fill_2
X_4431_ _1658_ _1923_ _1914_ _1708_ VGND VGND VPWR VPWR _2066_ sky130_fd_sc_hd__o22a_1
XANTENNA_1 _1846_ VGND VGND VPWR VPWR sky130_fd_sc_hd__diode_2
X_4500_ _2129_ VGND VGND VPWR VPWR _2130_ sky130_fd_sc_hd__inv_2
X_5480_ reg_file.memory\[1\]\[12\] VGND VGND VPWR VPWR _2738_ sky130_fd_sc_hd__clkbuf_1
X_6032_ clknet_leaf_9_clk _0267_ VGND VGND VPWR VPWR reg_file.memory\[8\]\[30\] sky130_fd_sc_hd__dfxtp_1
XFILLER_0_67_43 VGND VGND VPWR VPWR sky130_fd_sc_hd__fill_1
X_4293_ _1654_ _1920_ _1935_ _1072_ VGND VGND VPWR VPWR _1936_ sky130_fd_sc_hd__a211o_1
X_4362_ _1800_ VGND VGND VPWR VPWR _2001_ sky130_fd_sc_hd__buf_2
X_6101_ clknet_leaf_1_clk _0336_ VGND VGND VPWR VPWR reg_file.memory\[15\]\[3\] sky130_fd_sc_hd__dfxtp_1
X_3313_ reg_file.memory\[8\]\[11\] reg_file.memory\[9\]\[11\] _0637_ VGND VGND VPWR
+ VPWR _0978_ sky130_fd_sc_hd__mux2_1
X_3244_ _0904_ _0908_ _0611_ VGND VGND VPWR VPWR _0909_ sky130_fd_sc_hd__o21a_1
XFILLER_0_83_53 VGND VGND VPWR VPWR sky130_fd_sc_hd__decap_3
XTAP_TAPCELL_ROW_49_483 VGND VPWR sky130_fd_sc_hd__tapvpwrvgnd_1
X_3175_ reg_file.memory\[4\]\[19\] reg_file.memory\[5\]\[19\] _0593_ VGND VGND VPWR
+ VPWR _0840_ sky130_fd_sc_hd__mux2_1
X_5747_ clknet_leaf_6_clk _0031_ VGND VGND VPWR VPWR clk_div.counter\[2\] sky130_fd_sc_hd__dfxtp_1
X_2959_ _0623_ VGND VGND VPWR VPWR _0624_ sky130_fd_sc_hd__buf_4
X_5816_ _0519_ _0014_ VGND VGND VPWR VPWR alu.ALUResult\[22\] sky130_fd_sc_hd__dlxtn_1
XTAP_TAPCELL_ROW_32_383 VGND VPWR sky130_fd_sc_hd__tapvpwrvgnd_1
XFILLER_0_29_293 VGND VGND VPWR VPWR sky130_fd_sc_hd__fill_2
XFILLER_0_8_132 VGND VGND VPWR VPWR sky130_fd_sc_hd__fill_2
X_4629_ _1907_ _2240_ _2246_ _2247_ VGND VGND VPWR VPWR _0524_ sky130_fd_sc_hd__a211o_1
X_5678_ reg_file.memory\[2\]\[10\] VGND VGND VPWR VPWR _2842_ sky130_fd_sc_hd__clkbuf_1
XFILLER_0_35_252 VGND VGND VPWR VPWR sky130_fd_sc_hd__decap_4
Xoutput3 net3 VGND VGND VPWR VPWR an[0] sky130_fd_sc_hd__buf_1
XFILLER_0_37_57 VGND VGND VPWR VPWR sky130_fd_sc_hd__fill_2
X_4980_ _1334_ _1342_ _2404_ _2407_ VGND VGND VPWR VPWR _2474_ sky130_fd_sc_hd__or4_4
XTAP_TAPCELL_ROW_46_464 VGND VPWR sky130_fd_sc_hd__tapvpwrvgnd_1
X_5601_ _2802_ VGND VGND VPWR VPWR _0433_ sky130_fd_sc_hd__clkbuf_1
X_3862_ _1502_ _1509_ _1506_ _1507_ VGND VGND VPWR VPWR _1518_ sky130_fd_sc_hd__a31o_1
X_3931_ _1579_ _1582_ _1584_ _1586_ VGND VGND VPWR VPWR _1587_ sky130_fd_sc_hd__o211a_1
X_4414_ _1984_ _2049_ _1732_ VGND VGND VPWR VPWR _2050_ sky130_fd_sc_hd__mux2_1
X_5394_ _2413_ reg_file.memory\[15\]\[2\] _2691_ VGND VGND VPWR VPWR _2694_ sky130_fd_sc_hd__mux2_1
X_5532_ _2765_ VGND VGND VPWR VPWR _0401_ sky130_fd_sc_hd__clkbuf_1
X_5463_ _2729_ VGND VGND VPWR VPWR _0368_ sky130_fd_sc_hd__clkbuf_1
XFILLER_0_1_352 VPWR VGND VPWR VGND sky130_ef_sc_hd__decap_12
X_3793_ _1437_ _1443_ _1440_ VGND VGND VPWR VPWR _1449_ sky130_fd_sc_hd__a21o_1
X_4276_ _1916_ _1918_ _1733_ VGND VGND VPWR VPWR _1919_ sky130_fd_sc_hd__mux2_1
XFILLER_0_78_97 VPWR VGND VPWR VGND sky130_ef_sc_hd__decap_12
X_4345_ _1982_ _1984_ _1703_ VGND VGND VPWR VPWR _1985_ sky130_fd_sc_hd__mux2_1
X_3227_ reg_file.memory\[15\]\[16\] _0553_ _0617_ _0891_ VGND VGND VPWR VPWR _0892_
+ sky130_fd_sc_hd__a211o_1
X_6015_ clknet_leaf_25_clk _0250_ VGND VGND VPWR VPWR reg_file.memory\[8\]\[13\] sky130_fd_sc_hd__dfxtp_1
X_3089_ reg_file.memory\[25\]\[25\] _0753_ _0671_ VGND VGND VPWR VPWR _0754_ sky130_fd_sc_hd__mux2_1
X_3158_ reg_file.memory\[2\]\[20\] _0567_ _0574_ reg_file.memory\[7\]\[20\] _0580_
+ VGND VGND VPWR VPWR _0823_ sky130_fd_sc_hd__o221a_1
XFILLER_0_23_222 VGND VGND VPWR VPWR sky130_fd_sc_hd__fill_2
X_4061_ _1706_ VGND VGND VPWR VPWR _1707_ sky130_fd_sc_hd__buf_2
X_4130_ _1079_ _1669_ VGND VGND VPWR VPWR _1776_ sky130_fd_sc_hd__nand2_1
XFILLER_0_48_89 VGND VGND VPWR VPWR sky130_fd_sc_hd__fill_1
X_3012_ reg_file.memory\[0\]\[29\] reg_file.memory\[1\]\[29\] _0595_ VGND VGND VPWR
+ VPWR _0677_ sky130_fd_sc_hd__mux2_1
XFILLER_0_58_141 VGND VGND VPWR VPWR sky130_fd_sc_hd__decap_6
X_4963_ alu.ALUResult\[26\] VGND VGND VPWR VPWR _2463_ sky130_fd_sc_hd__dlymetal6s2s_1
XFILLER_0_73_166 VGND VGND VPWR VPWR sky130_fd_sc_hd__fill_2
XFILLER_0_73_111 VGND VGND VPWR VPWR sky130_fd_sc_hd__fill_1
X_4894_ _2416_ VGND VGND VPWR VPWR _0112_ sky130_fd_sc_hd__clkbuf_1
X_3845_ _1496_ _1493_ VGND VGND VPWR VPWR _1501_ sky130_fd_sc_hd__nor2_1
X_3914_ _1569_ VGND VGND VPWR VPWR _1570_ sky130_fd_sc_hd__inv_4
X_3776_ _1430_ _1431_ VGND VGND VPWR VPWR _1432_ sky130_fd_sc_hd__nand2_1
X_5515_ _2755_ VGND VGND VPWR VPWR _0394_ sky130_fd_sc_hd__clkbuf_1
X_5377_ reg_file.memory\[10\]\[27\] alu.ALUResult\[27\] _2676_ VGND VGND VPWR VPWR
+ _2684_ sky130_fd_sc_hd__mux2_1
X_5446_ _2465_ reg_file.memory\[15\]\[27\] _2713_ VGND VGND VPWR VPWR _2721_ sky130_fd_sc_hd__mux2_1
X_4328_ _1925_ _1968_ _1687_ VGND VGND VPWR VPWR _1969_ sky130_fd_sc_hd__mux2_1
X_4259_ _1178_ _1900_ _1901_ _1902_ VGND VGND VPWR VPWR _1903_ sky130_fd_sc_hd__o31a_1
XTAP_TAPCELL_ROW_65_581 VGND VPWR sky130_fd_sc_hd__tapvpwrvgnd_1
XFILLER_0_49_185 VGND VGND VPWR VPWR sky130_fd_sc_hd__fill_2
XFILLER_0_87_236 VGND VGND VPWR VPWR sky130_fd_sc_hd__fill_1
XFILLER_0_70_114 VGND VGND VPWR VPWR sky130_fd_sc_hd__fill_1
XFILLER_0_55_188 VPWR VGND VPWR VGND sky130_ef_sc_hd__decap_12
XFILLER_0_50_68 VGND VGND VPWR VPWR sky130_fd_sc_hd__decap_6
X_3630_ _1185_ _1186_ _1188_ VGND VGND VPWR VPWR _1295_ sky130_fd_sc_hd__nand3_1
XFILLER_0_28_358 VGND VGND VPWR VPWR sky130_fd_sc_hd__fill_2
X_3492_ _1155_ _1156_ VGND VGND VPWR VPWR _1157_ sky130_fd_sc_hd__or2_1
XFILLER_0_59_77 VPWR VGND VPWR VGND sky130_ef_sc_hd__decap_12
X_3561_ _0782_ _0789_ VGND VGND VPWR VPWR _1226_ sky130_fd_sc_hd__nand2_1
X_5300_ _2643_ VGND VGND VPWR VPWR _0291_ sky130_fd_sc_hd__clkbuf_1
X_5231_ reg_file.memory\[8\]\[20\] alu.ALUResult\[20\] _2608_ VGND VGND VPWR VPWR
+ _2609_ sky130_fd_sc_hd__mux2_1
XTAP_TAPCELL_ROW_79_662 VGND VPWR sky130_fd_sc_hd__tapvpwrvgnd_1
X_4044_ _0853_ _1671_ VGND VGND VPWR VPWR _1690_ sky130_fd_sc_hd__nand2_1
X_4113_ _1682_ _1756_ _1758_ VGND VGND VPWR VPWR _1759_ sky130_fd_sc_hd__a21bo_1
X_5093_ _2450_ reg_file.memory\[6\]\[20\] _2534_ VGND VGND VPWR VPWR _2535_ sky130_fd_sc_hd__mux2_1
X_5162_ _2571_ VGND VGND VPWR VPWR _0225_ sky130_fd_sc_hd__clkbuf_1
X_5995_ clknet_leaf_11_clk _0230_ VGND VGND VPWR VPWR reg_file.memory\[7\]\[25\] sky130_fd_sc_hd__dfxtp_1
XTAP_TAPCELL_ROW_62_562 VGND VPWR sky130_fd_sc_hd__tapvpwrvgnd_1
X_4946_ _2450_ reg_file.memory\[4\]\[20\] _2451_ VGND VGND VPWR VPWR _2452_ sky130_fd_sc_hd__mux2_1
X_4877_ _0537_ _0547_ _1329_ VGND VGND VPWR VPWR _2403_ sky130_fd_sc_hd__o21a_1
X_3759_ _1407_ _1403_ _1414_ VGND VGND VPWR VPWR _1415_ sky130_fd_sc_hd__o21ai_2
X_3828_ _1473_ _1476_ _1481_ _1364_ VGND VGND VPWR VPWR _1484_ sky130_fd_sc_hd__a2bb2o_1
X_5429_ _2448_ reg_file.memory\[15\]\[19\] _2702_ VGND VGND VPWR VPWR _2712_ sky130_fd_sc_hd__mux2_1
XTAP_TAPCELL_ROW_85_698 VGND VPWR sky130_fd_sc_hd__tapvpwrvgnd_1
XFILLER_0_69_225 VGND VGND VPWR VPWR sky130_fd_sc_hd__decap_8
XFILLER_0_52_103 VGND VGND VPWR VPWR sky130_fd_sc_hd__fill_1
XFILLER_0_37_166 VGND VGND VPWR VPWR sky130_fd_sc_hd__fill_2
XFILLER_0_37_133 VGND VGND VPWR VPWR sky130_fd_sc_hd__fill_1
XFILLER_0_45_13 VGND VGND VPWR VPWR sky130_fd_sc_hd__fill_2
XFILLER_0_75_228 VGND VGND VPWR VPWR sky130_fd_sc_hd__fill_2
X_2992_ reg_file.memory\[0\]\[30\] _0651_ _0656_ VGND VGND VPWR VPWR _0657_ sky130_fd_sc_hd__mux2_1
XFILLER_0_45_57 VGND VGND VPWR VPWR sky130_fd_sc_hd__fill_2
X_5780_ clk_div.slow_clk _0063_ VGND VGND VPWR VPWR seven_seg_conv.temp\[16\] sky130_fd_sc_hd__dfxtp_1
XFILLER_0_0_15 VGND VGND VPWR VPWR sky130_fd_sc_hd__fill_1
XFILLER_0_0_37 VGND VGND VPWR VPWR sky130_fd_sc_hd__fill_1
X_4800_ _2364_ VGND VGND VPWR VPWR _0070_ sky130_fd_sc_hd__clkbuf_1
X_4731_ clk_div.counter\[12\] _2321_ clk_div.counter\[13\] VGND VGND VPWR VPWR _2324_
+ sky130_fd_sc_hd__a21o_1
X_4662_ _1742_ _2276_ _2277_ _2100_ _2129_ VGND VGND VPWR VPWR _2278_ sky130_fd_sc_hd__a311o_1
X_4593_ _2019_ _2135_ _2210_ _2214_ VGND VGND VPWR VPWR _2215_ sky130_fd_sc_hd__or4_1
X_3613_ _1207_ _1277_ VGND VGND VPWR VPWR _1278_ sky130_fd_sc_hd__xnor2_1
XFILLER_0_28_144 VGND VGND VPWR VPWR sky130_fd_sc_hd__fill_1
XFILLER_0_9_79 VGND VGND VPWR VPWR sky130_fd_sc_hd__fill_1
XTAP_TAPCELL_ROW_16_286 VGND VPWR sky130_fd_sc_hd__tapvpwrvgnd_1
XFILLER_0_16_306 VGND VGND VPWR VPWR sky130_fd_sc_hd__fill_2
X_6263_ clk_div.slow_clk _0498_ VGND VGND VPWR VPWR net6 sky130_fd_sc_hd__dfxtp_1
X_3475_ _1138_ _1139_ _0570_ VGND VGND VPWR VPWR _1140_ sky130_fd_sc_hd__mux2_1
XFILLER_0_51_180 VGND VGND VPWR VPWR sky130_fd_sc_hd__decap_6
X_6194_ clknet_leaf_3_clk _0429_ VGND VGND VPWR VPWR reg_file.memory\[25\]\[0\] sky130_fd_sc_hd__dfxtp_1
X_3544_ _0951_ _1207_ _1208_ VGND VGND VPWR VPWR _1209_ sky130_fd_sc_hd__a21o_1
X_5214_ reg_file.memory\[8\]\[12\] alu.ALUResult\[12\] _2597_ VGND VGND VPWR VPWR
+ _2600_ sky130_fd_sc_hd__mux2_1
X_4027_ _1659_ _1672_ VGND VGND VPWR VPWR _1673_ sky130_fd_sc_hd__nand2_1
XFILLER_0_36_3 VGND VGND VPWR VPWR sky130_fd_sc_hd__decap_4
X_5145_ _2562_ VGND VGND VPWR VPWR _0217_ sky130_fd_sc_hd__clkbuf_1
X_5076_ _2434_ reg_file.memory\[6\]\[12\] _2523_ VGND VGND VPWR VPWR _2526_ sky130_fd_sc_hd__mux2_1
XFILLER_0_19_80 VGND VGND VPWR VPWR sky130_fd_sc_hd__fill_2
XFILLER_0_66_217 VGND VGND VPWR VPWR sky130_fd_sc_hd__decap_3
X_5978_ clknet_leaf_23_clk _0213_ VGND VGND VPWR VPWR reg_file.memory\[7\]\[8\] sky130_fd_sc_hd__dfxtp_1
X_4929_ alu.ALUResult\[15\] VGND VGND VPWR VPWR _2440_ sky130_fd_sc_hd__buf_1
XTAP_TAPCELL_ROW_7_232 VGND VPWR sky130_fd_sc_hd__tapvpwrvgnd_1
XPHY_EDGE_ROW_8_Left_99 VGND VGND VPWR VPWR sky130_fd_sc_hd__decap_3
XFILLER_0_57_217 VGND VGND VPWR VPWR sky130_fd_sc_hd__decap_6
XTAP_TAPCELL_ROW_13_267 VGND VPWR sky130_fd_sc_hd__tapvpwrvgnd_1
XFILLER_0_0_269 VGND VGND VPWR VPWR sky130_fd_sc_hd__decap_8
XFILLER_0_0_247 VGND VGND VPWR VPWR sky130_fd_sc_hd__fill_1
XFILLER_0_0_225 VGND VGND VPWR VPWR sky130_fd_sc_hd__decap_8
XFILLER_0_0_214 VGND VGND VPWR VPWR sky130_fd_sc_hd__decap_8
X_3260_ _0920_ _0924_ _0611_ VGND VGND VPWR VPWR _0925_ sky130_fd_sc_hd__o21a_1
X_5901_ clknet_leaf_13_clk _0136_ VGND VGND VPWR VPWR reg_file.memory\[4\]\[27\] sky130_fd_sc_hd__dfxtp_1
X_3191_ reg_file.memory\[4\]\[18\] reg_file.memory\[5\]\[18\] _0593_ VGND VGND VPWR
+ VPWR _0856_ sky130_fd_sc_hd__mux2_1
X_4714_ clk_div.counter\[6\] _2312_ _2302_ VGND VGND VPWR VPWR _2314_ sky130_fd_sc_hd__o21ai_1
X_5763_ clknet_leaf_6_clk _0015_ VGND VGND VPWR VPWR ctrl_unit.RegWrite sky130_fd_sc_hd__dfxtp_1
X_2975_ _0639_ VGND VGND VPWR VPWR _0640_ sky130_fd_sc_hd__clkbuf_4
XFILLER_0_8_358 VGND VGND VPWR VPWR sky130_fd_sc_hd__decap_6
X_5832_ clknet_leaf_26_clk _0082_ VGND VGND VPWR VPWR reg_file.memory\[9\]\[6\] sky130_fd_sc_hd__dfxtp_1
X_4645_ _2260_ _1240_ _2258_ _1907_ VGND VGND VPWR VPWR _2262_ sky130_fd_sc_hd__o31ai_1
X_4576_ _2197_ _1264_ _2187_ _1907_ VGND VGND VPWR VPWR _2199_ sky130_fd_sc_hd__o31ai_1
X_3527_ _1064_ _1189_ _1191_ VGND VGND VPWR VPWR _1192_ sky130_fd_sc_hd__a21o_1
X_5694_ reg_file.memory\[2\]\[18\] VGND VGND VPWR VPWR _2850_ sky130_fd_sc_hd__clkbuf_1
X_3458_ reg_file.memory\[2\]\[2\] _0673_ _0597_ reg_file.memory\[7\]\[2\] _0604_ VGND
+ VGND VPWR VPWR _1123_ sky130_fd_sc_hd__a221o_1
X_3389_ reg_file.memory\[15\]\[6\] _0552_ _0616_ VGND VGND VPWR VPWR _1054_ sky130_fd_sc_hd__a21oi_1
X_6246_ clknet_leaf_15_clk _0481_ VGND VGND VPWR VPWR reg_file.memory\[2\]\[20\] sky130_fd_sc_hd__dfxtp_1
X_5128_ _2553_ VGND VGND VPWR VPWR _0209_ sky130_fd_sc_hd__clkbuf_1
X_6177_ clknet_leaf_22_clk _0412_ VGND VGND VPWR VPWR reg_file.memory\[21\]\[15\]
+ sky130_fd_sc_hd__dfxtp_1
XTAP_TAPCELL_ROW_4_213 VGND VPWR sky130_fd_sc_hd__tapvpwrvgnd_1
X_5059_ _2417_ reg_file.memory\[6\]\[4\] _2512_ VGND VGND VPWR VPWR _2517_ sky130_fd_sc_hd__mux2_1
XFILLER_0_62_253 VGND VGND VPWR VPWR sky130_fd_sc_hd__fill_2
XFILLER_0_47_294 VGND VGND VPWR VPWR sky130_fd_sc_hd__fill_1
XTAP_TAPCELL_ROW_10_248 VGND VPWR sky130_fd_sc_hd__tapvpwrvgnd_1
X_4430_ _1927_ _2060_ _2063_ _2064_ VGND VGND VPWR VPWR _2065_ sky130_fd_sc_hd__o22a_1
XANTENNA_2 _2027_ VGND VGND VPWR VPWR sky130_fd_sc_hd__diode_2
X_6031_ clknet_leaf_9_clk _0266_ VGND VGND VPWR VPWR reg_file.memory\[8\]\[29\] sky130_fd_sc_hd__dfxtp_1
X_4292_ _1707_ _1923_ _1929_ _1934_ VGND VGND VPWR VPWR _1935_ sky130_fd_sc_hd__o211a_1
X_6100_ clknet_leaf_4_clk _0335_ VGND VGND VPWR VPWR reg_file.memory\[15\]\[2\] sky130_fd_sc_hd__dfxtp_1
X_4361_ _1997_ _1998_ _1999_ VGND VGND VPWR VPWR _2000_ sky130_fd_sc_hd__and3b_1
XFILLER_0_6_36 VPWR VGND VPWR VGND sky130_ef_sc_hd__decap_12
X_3243_ _0573_ _0905_ _0907_ _0606_ VGND VGND VPWR VPWR _0908_ sky130_fd_sc_hd__o211a_1
X_3312_ reg_file.memory\[0\]\[11\] _0976_ _0654_ VGND VGND VPWR VPWR _0977_ sky130_fd_sc_hd__mux2_1
XFILLER_0_88_194 VGND VGND VPWR VPWR sky130_fd_sc_hd__fill_2
XTAP_TAPCELL_ROW_49_484 VGND VPWR sky130_fd_sc_hd__tapvpwrvgnd_1
X_3174_ reg_file.memory\[2\]\[19\] _0567_ _0573_ reg_file.memory\[7\]\[19\] _0580_
+ VGND VGND VPWR VPWR _0839_ sky130_fd_sc_hd__o221a_1
X_5746_ clknet_leaf_6_clk _0030_ VGND VGND VPWR VPWR clk_div.counter\[1\] sky130_fd_sc_hd__dfxtp_1
X_2958_ _0538_ _0541_ _0620_ _0622_ VGND VGND VPWR VPWR _0623_ sky130_fd_sc_hd__a31oi_4
X_5815_ _0518_ _0014_ VGND VGND VPWR VPWR alu.ALUResult\[21\] sky130_fd_sc_hd__dlxtn_1
XFILLER_0_44_253 VGND VGND VPWR VPWR sky130_fd_sc_hd__decap_8
XFILLER_0_44_231 VGND VGND VPWR VPWR sky130_fd_sc_hd__fill_2
XFILLER_0_36_209 VGND VGND VPWR VPWR sky130_fd_sc_hd__fill_2
XTAP_TAPCELL_ROW_32_384 VGND VPWR sky130_fd_sc_hd__tapvpwrvgnd_1
X_5677_ _2841_ VGND VGND VPWR VPWR _0470_ sky130_fd_sc_hd__clkbuf_1
XFILLER_0_8_177 VGND VGND VPWR VPWR sky130_fd_sc_hd__decap_3
X_4628_ _1319_ _2059_ VGND VGND VPWR VPWR _2247_ sky130_fd_sc_hd__nor2_1
X_4559_ _1902_ _2183_ VGND VGND VPWR VPWR _2184_ sky130_fd_sc_hd__nor2_1
X_2889_ _0553_ VGND VGND VPWR VPWR _0554_ sky130_fd_sc_hd__buf_2
X_6229_ clknet_leaf_1_clk _0464_ VGND VGND VPWR VPWR reg_file.memory\[2\]\[3\] sky130_fd_sc_hd__dfxtp_1
Xoutput4 net4 VGND VGND VPWR VPWR an[1] sky130_fd_sc_hd__buf_1
XTAP_TAPCELL_ROW_46_465 VGND VPWR sky130_fd_sc_hd__tapvpwrvgnd_1
X_3930_ _1585_ VGND VGND VPWR VPWR _1586_ sky130_fd_sc_hd__clkinvlp_2
X_5531_ _2417_ reg_file.memory\[21\]\[4\] _2760_ VGND VGND VPWR VPWR _2765_ sky130_fd_sc_hd__mux2_1
X_5600_ _2417_ reg_file.memory\[25\]\[4\] _2797_ VGND VGND VPWR VPWR _2802_ sky130_fd_sc_hd__mux2_1
X_3861_ _1511_ _1510_ _1512_ VGND VGND VPWR VPWR _1517_ sky130_fd_sc_hd__or3_1
X_3792_ _1368_ VGND VGND VPWR VPWR _1448_ sky130_fd_sc_hd__inv_2
X_4413_ _2022_ _2048_ _1686_ VGND VGND VPWR VPWR _2049_ sky130_fd_sc_hd__mux2_1
X_4344_ _1941_ _1983_ _1686_ VGND VGND VPWR VPWR _1984_ sky130_fd_sc_hd__mux2_1
X_5393_ _2693_ VGND VGND VPWR VPWR _0334_ sky130_fd_sc_hd__clkbuf_1
XFILLER_0_41_223 VGND VGND VPWR VPWR sky130_fd_sc_hd__fill_1
X_5462_ reg_file.memory\[1\]\[3\] VGND VGND VPWR VPWR _2729_ sky130_fd_sc_hd__clkbuf_1
X_4275_ _1819_ _1826_ _1917_ VGND VGND VPWR VPWR _1918_ sky130_fd_sc_hd__o21ai_1
X_3157_ _0814_ _0821_ VGND VGND VPWR VPWR _0822_ sky130_fd_sc_hd__nand2_1
X_6014_ clknet_leaf_25_clk _0249_ VGND VGND VPWR VPWR reg_file.memory\[8\]\[12\] sky130_fd_sc_hd__dfxtp_1
X_3226_ _0886_ _0890_ _0611_ VGND VGND VPWR VPWR _0891_ sky130_fd_sc_hd__o21a_1
X_3088_ _0750_ _0752_ _0665_ VGND VGND VPWR VPWR _0753_ sky130_fd_sc_hd__mux2_1
XFILLER_0_68_109 VPWR VGND VPWR VGND sky130_ef_sc_hd__decap_12
XFILLER_0_43_90 VGND VGND VPWR VPWR sky130_fd_sc_hd__fill_2
XTAP_TAPCELL_ROW_37_410 VGND VPWR sky130_fd_sc_hd__tapvpwrvgnd_1
X_5729_ _0020_ seven_seg_conv.digit_counter\[1\] _2867_ net8 _2296_ VGND VGND VPWR
+ VPWR _0496_ sky130_fd_sc_hd__o32a_1
XFILLER_0_76_197 VGND VGND VPWR VPWR sky130_fd_sc_hd__decap_8
XTAP_TAPCELL_ROW_20_310 VGND VPWR sky130_fd_sc_hd__tapvpwrvgnd_1
XTAP_TAPCELL_ROW_43_446 VGND VPWR sky130_fd_sc_hd__tapvpwrvgnd_1
XFILLER_0_48_24 VGND VGND VPWR VPWR sky130_fd_sc_hd__decap_4
XPHY_EDGE_ROW_39_Left_130 VGND VGND VPWR VPWR sky130_fd_sc_hd__decap_3
X_3011_ reg_file.memory\[4\]\[29\] reg_file.memory\[5\]\[29\] _0595_ VGND VGND VPWR
+ VPWR _0676_ sky130_fd_sc_hd__mux2_1
X_4060_ _1108_ _1656_ VGND VGND VPWR VPWR _1706_ sky130_fd_sc_hd__or2_1
XFILLER_0_48_68 VGND VGND VPWR VPWR sky130_fd_sc_hd__decap_8
X_4962_ _2462_ VGND VGND VPWR VPWR _0134_ sky130_fd_sc_hd__clkbuf_1
XFILLER_0_64_78 VGND VGND VPWR VPWR sky130_fd_sc_hd__decap_6
X_4893_ _2415_ reg_file.memory\[4\]\[3\] _2409_ VGND VGND VPWR VPWR _2416_ sky130_fd_sc_hd__mux2_1
X_3913_ seven_seg_conv.temp\[6\] alu.ALUResult\[6\] _1347_ VGND VGND VPWR VPWR _1569_
+ sky130_fd_sc_hd__mux2_1
X_5514_ reg_file.memory\[1\]\[29\] VGND VGND VPWR VPWR _2755_ sky130_fd_sc_hd__clkbuf_1
XFILLER_0_80_77 VGND VGND VPWR VPWR sky130_fd_sc_hd__fill_1
XFILLER_0_73_156 VGND VGND VPWR VPWR sky130_fd_sc_hd__fill_1
X_3844_ _1499_ _1497_ _1492_ _1490_ VGND VGND VPWR VPWR _1500_ sky130_fd_sc_hd__o2bb2a_1
X_3775_ _1428_ _1429_ _1427_ VGND VGND VPWR VPWR _1431_ sky130_fd_sc_hd__a21o_1
X_4327_ _1841_ _1832_ VGND VGND VPWR VPWR _1968_ sky130_fd_sc_hd__nand2_1
XFILLER_0_66_3 VGND VGND VPWR VPWR sky130_fd_sc_hd__fill_1
X_5376_ _2683_ VGND VGND VPWR VPWR _0327_ sky130_fd_sc_hd__clkbuf_1
X_5445_ _2720_ VGND VGND VPWR VPWR _0359_ sky130_fd_sc_hd__clkbuf_1
X_4189_ _1679_ _1782_ VGND VGND VPWR VPWR _1834_ sky130_fd_sc_hd__nand2_1
X_4258_ _1875_ VGND VGND VPWR VPWR _1902_ sky130_fd_sc_hd__clkbuf_4
X_3209_ _0573_ _0871_ _0873_ _0606_ VGND VGND VPWR VPWR _0874_ sky130_fd_sc_hd__o211a_1
XTAP_TAPCELL_ROW_65_582 VGND VPWR sky130_fd_sc_hd__tapvpwrvgnd_1
XFILLER_0_60_362 VGND VGND VPWR VPWR sky130_fd_sc_hd__fill_2
XFILLER_0_20_248 VGND VGND VPWR VPWR sky130_fd_sc_hd__fill_1
XFILLER_0_34_26 VGND VGND VPWR VPWR sky130_fd_sc_hd__fill_2
XPHY_EDGE_ROW_16_Right_16 VGND VGND VPWR VPWR sky130_fd_sc_hd__decap_3
XFILLER_0_55_167 VGND VGND VPWR VPWR sky130_fd_sc_hd__fill_1
XFILLER_0_55_145 VPWR VGND VPWR VGND sky130_ef_sc_hd__decap_12
X_3560_ _0798_ _0805_ _0806_ _1224_ VGND VGND VPWR VPWR _1225_ sky130_fd_sc_hd__o2bb2a_1
XFILLER_0_43_307 VGND VGND VPWR VPWR sky130_fd_sc_hd__fill_2
XPHY_EDGE_ROW_25_Right_25 VGND VGND VPWR VPWR sky130_fd_sc_hd__decap_3
X_3491_ _1154_ _1152_ VGND VGND VPWR VPWR _1156_ sky130_fd_sc_hd__nor2_1
XFILLER_0_59_89 VPWR VGND VPWR VGND sky130_ef_sc_hd__decap_12
XFILLER_0_51_362 VGND VGND VPWR VPWR sky130_fd_sc_hd__fill_2
X_5161_ _2450_ reg_file.memory\[7\]\[20\] _2570_ VGND VGND VPWR VPWR _2571_ sky130_fd_sc_hd__mux2_1
X_5230_ _2585_ VGND VGND VPWR VPWR _2608_ sky130_fd_sc_hd__buf_4
X_4043_ _1679_ VGND VGND VPWR VPWR _1689_ sky130_fd_sc_hd__buf_2
XTAP_TAPCELL_ROW_79_663 VGND VPWR sky130_fd_sc_hd__tapvpwrvgnd_1
XFILLER_0_75_88 VGND VGND VPWR VPWR sky130_fd_sc_hd__decap_4
XFILLER_0_75_66 VGND VGND VPWR VPWR sky130_fd_sc_hd__fill_2
X_4112_ _1659_ _1757_ VGND VGND VPWR VPWR _1758_ sky130_fd_sc_hd__nand2_1
X_5092_ _2511_ VGND VGND VPWR VPWR _2534_ sky130_fd_sc_hd__buf_4
XPHY_EDGE_ROW_34_Right_34 VGND VGND VPWR VPWR sky130_fd_sc_hd__decap_3
XFILLER_0_86_281 VGND VGND VPWR VPWR sky130_fd_sc_hd__fill_2
X_4876_ _1334_ VGND VGND VPWR VPWR _2402_ sky130_fd_sc_hd__inv_2
X_5994_ clknet_leaf_11_clk _0229_ VGND VGND VPWR VPWR reg_file.memory\[7\]\[24\] sky130_fd_sc_hd__dfxtp_1
XTAP_TAPCELL_ROW_62_563 VGND VPWR sky130_fd_sc_hd__tapvpwrvgnd_1
X_4945_ _2408_ VGND VGND VPWR VPWR _2451_ sky130_fd_sc_hd__buf_4
XFILLER_0_24_70 VGND VGND VPWR VPWR sky130_fd_sc_hd__fill_2
XFILLER_0_61_104 VGND VGND VPWR VPWR sky130_fd_sc_hd__fill_1
X_3689_ _1345_ VGND VGND VPWR VPWR _1346_ sky130_fd_sc_hd__buf_4
XPHY_EDGE_ROW_43_Right_43 VGND VGND VPWR VPWR sky130_fd_sc_hd__decap_3
X_3758_ _1403_ _1404_ VGND VGND VPWR VPWR _1414_ sky130_fd_sc_hd__nand2_1
X_3827_ seven_seg_conv.temp\[16\] alu.ALUResult\[16\] _1346_ VGND VGND VPWR VPWR _1483_
+ sky130_fd_sc_hd__mux2_1
XPHY_EDGE_ROW_52_Right_52 VGND VGND VPWR VPWR sky130_fd_sc_hd__decap_3
X_5428_ _2711_ VGND VGND VPWR VPWR _0351_ sky130_fd_sc_hd__clkbuf_1
X_5359_ _2674_ VGND VGND VPWR VPWR _0319_ sky130_fd_sc_hd__clkbuf_1
XTAP_TAPCELL_ROW_85_699 VGND VPWR sky130_fd_sc_hd__tapvpwrvgnd_1
XFILLER_0_69_237 VPWR VGND VPWR VGND sky130_ef_sc_hd__decap_12
XPHY_EDGE_ROW_61_Right_61 VGND VGND VPWR VPWR sky130_fd_sc_hd__decap_3
XPHY_EDGE_ROW_70_Right_70 VGND VGND VPWR VPWR sky130_fd_sc_hd__decap_3
XFILLER_0_33_362 VGND VGND VPWR VPWR sky130_fd_sc_hd__fill_2
XTAP_TAPCELL_ROW_76_644 VGND VPWR sky130_fd_sc_hd__tapvpwrvgnd_1
X_4730_ clk_div.counter\[12\] _2321_ _2323_ VGND VGND VPWR VPWR _0041_ sky130_fd_sc_hd__o21a_1
XFILLER_0_61_46 VGND VGND VPWR VPWR sky130_fd_sc_hd__fill_1
X_2991_ _0655_ VGND VGND VPWR VPWR _0656_ sky130_fd_sc_hd__buf_4
XFILLER_0_0_27 VGND VGND VPWR VPWR sky130_fd_sc_hd__fill_1
XTAP_TAPCELL_ROW_16_287 VGND VPWR sky130_fd_sc_hd__tapvpwrvgnd_1
X_4661_ _1963_ _2211_ _2233_ _1737_ VGND VGND VPWR VPWR _2277_ sky130_fd_sc_hd__a211o_1
X_4592_ _1768_ _2212_ _2213_ _1742_ VGND VGND VPWR VPWR _2214_ sky130_fd_sc_hd__o211a_1
X_3612_ _0951_ _1276_ VGND VGND VPWR VPWR _1277_ sky130_fd_sc_hd__nand2_1
X_3543_ _0943_ _0950_ VGND VGND VPWR VPWR _1208_ sky130_fd_sc_hd__nor2_1
XFILLER_0_3_278 VGND VGND VPWR VPWR sky130_fd_sc_hd__fill_2
X_6262_ clk_div.slow_clk _0497_ VGND VGND VPWR VPWR net7 sky130_fd_sc_hd__dfxtp_1
X_3474_ reg_file.memory\[0\]\[1\] reg_file.memory\[1\]\[1\] _0588_ VGND VGND VPWR
+ VPWR _1139_ sky130_fd_sc_hd__mux2_1
X_6193_ clknet_leaf_14_clk _0428_ VGND VGND VPWR VPWR reg_file.memory\[21\]\[31\]
+ sky130_fd_sc_hd__dfxtp_1
X_5144_ _2434_ reg_file.memory\[7\]\[12\] _2559_ VGND VGND VPWR VPWR _2562_ sky130_fd_sc_hd__mux2_1
XMain_18 VGND VGND VPWR VPWR cx[0] Main_18/LO sky130_fd_sc_hd__conb_1
X_5213_ _2599_ VGND VGND VPWR VPWR _0248_ sky130_fd_sc_hd__clkbuf_1
X_4026_ _0789_ _1671_ VGND VGND VPWR VPWR _1672_ sky130_fd_sc_hd__nand2_1
XFILLER_0_29_3 VGND VGND VPWR VPWR sky130_fd_sc_hd__fill_1
X_5075_ _2525_ VGND VGND VPWR VPWR _0184_ sky130_fd_sc_hd__clkbuf_1
X_4859_ _2393_ VGND VGND VPWR VPWR _0100_ sky130_fd_sc_hd__clkbuf_1
X_5977_ clknet_leaf_0_clk _0212_ VGND VGND VPWR VPWR reg_file.memory\[7\]\[7\] sky130_fd_sc_hd__dfxtp_1
X_4928_ _2439_ VGND VGND VPWR VPWR _0123_ sky130_fd_sc_hd__clkbuf_1
XFILLER_0_42_192 VGND VGND VPWR VPWR sky130_fd_sc_hd__decap_4
XFILLER_0_42_181 VGND VGND VPWR VPWR sky130_fd_sc_hd__fill_2
XTAP_TAPCELL_ROW_7_233 VGND VPWR sky130_fd_sc_hd__tapvpwrvgnd_1
XFILLER_0_65_251 VGND VGND VPWR VPWR sky130_fd_sc_hd__decap_8
XFILLER_0_65_284 VGND VGND VPWR VPWR sky130_fd_sc_hd__decap_6
XTAP_TAPCELL_ROW_13_268 VGND VPWR sky130_fd_sc_hd__tapvpwrvgnd_1
X_3190_ reg_file.memory\[7\]\[18\] _0674_ _0599_ reg_file.memory\[2\]\[18\] _0580_
+ VGND VGND VPWR VPWR _0855_ sky130_fd_sc_hd__o221a_1
X_5900_ clknet_leaf_16_clk _0135_ VGND VGND VPWR VPWR reg_file.memory\[4\]\[26\] sky130_fd_sc_hd__dfxtp_1
X_4713_ _2312_ _2313_ VGND VGND VPWR VPWR _0034_ sky130_fd_sc_hd__nor2_1
X_5762_ clknet_leaf_7_clk _0046_ VGND VGND VPWR VPWR clk_div.counter\[17\] sky130_fd_sc_hd__dfxtp_1
X_2974_ _0638_ VGND VGND VPWR VPWR _0639_ sky130_fd_sc_hd__clkbuf_4
X_5831_ clknet_leaf_26_clk _0081_ VGND VGND VPWR VPWR reg_file.memory\[9\]\[5\] sky130_fd_sc_hd__dfxtp_1
X_5693_ _2849_ VGND VGND VPWR VPWR _0478_ sky130_fd_sc_hd__clkbuf_1
X_4644_ _2260_ _2258_ _1240_ VGND VGND VPWR VPWR _2261_ sky130_fd_sc_hd__o21a_1
X_4575_ _2197_ _2187_ _1264_ VGND VGND VPWR VPWR _2198_ sky130_fd_sc_hd__o21a_1
X_3526_ _1046_ _1190_ VGND VGND VPWR VPWR _1191_ sky130_fd_sc_hd__nand2_1
X_6245_ clknet_leaf_17_clk _0480_ VGND VGND VPWR VPWR reg_file.memory\[2\]\[19\] sky130_fd_sc_hd__dfxtp_1
X_3457_ _1120_ _1121_ _0570_ VGND VGND VPWR VPWR _1122_ sky130_fd_sc_hd__mux2_1
X_5058_ _2516_ VGND VGND VPWR VPWR _0176_ sky130_fd_sc_hd__clkbuf_1
X_5127_ _2417_ reg_file.memory\[7\]\[4\] _2548_ VGND VGND VPWR VPWR _2553_ sky130_fd_sc_hd__mux2_1
X_3388_ _1048_ _1052_ _0610_ VGND VGND VPWR VPWR _1053_ sky130_fd_sc_hd__o21ai_1
X_6176_ clknet_leaf_22_clk _0411_ VGND VGND VPWR VPWR reg_file.memory\[21\]\[14\]
+ sky130_fd_sc_hd__dfxtp_1
XTAP_TAPCELL_ROW_4_214 VGND VPWR sky130_fd_sc_hd__tapvpwrvgnd_1
XPHY_EDGE_ROW_2_Right_2 VGND VGND VPWR VPWR sky130_fd_sc_hd__decap_3
X_4009_ alu.ALUControl\[1\] alu.ALUControl\[2\] VGND VGND VPWR VPWR _1655_ sky130_fd_sc_hd__nor2b_2
XFILLER_0_46_90 VPWR VGND VPWR VGND sky130_ef_sc_hd__decap_12
XFILLER_0_62_243 VGND VGND VPWR VPWR sky130_fd_sc_hd__fill_2
XTAP_TAPCELL_ROW_10_249 VGND VPWR sky130_fd_sc_hd__tapvpwrvgnd_1
XFILLER_0_30_195 VGND VGND VPWR VPWR sky130_fd_sc_hd__fill_1
XPHY_EDGE_ROW_11_Left_102 VGND VGND VPWR VPWR sky130_fd_sc_hd__decap_3
XFILLER_0_85_346 VGND VGND VPWR VPWR sky130_fd_sc_hd__fill_2
XANTENNA_3 _2047_ VGND VGND VPWR VPWR sky130_fd_sc_hd__diode_2
X_4360_ _1795_ VGND VGND VPWR VPWR _1999_ sky130_fd_sc_hd__buf_2
XFILLER_0_6_15 VPWR VGND VPWR VGND sky130_ef_sc_hd__decap_12
XFILLER_0_6_48 VPWR VGND VPWR VGND sky130_ef_sc_hd__decap_12
X_3311_ reg_file.memory\[5\]\[11\] _0975_ _0646_ VGND VGND VPWR VPWR _0976_ sky130_fd_sc_hd__mux2_1
XPHY_EDGE_ROW_20_Left_111 VGND VGND VPWR VPWR sky130_fd_sc_hd__decap_3
X_6030_ clknet_leaf_9_clk _0265_ VGND VGND VPWR VPWR reg_file.memory\[8\]\[28\] sky130_fd_sc_hd__dfxtp_1
X_4291_ _1737_ _1931_ _1933_ _1657_ VGND VGND VPWR VPWR _1934_ sky130_fd_sc_hd__a211o_1
X_3173_ _0830_ _0837_ VGND VGND VPWR VPWR _0838_ sky130_fd_sc_hd__xnor2_2
X_3242_ _0599_ _0906_ VGND VGND VPWR VPWR _0907_ sky130_fd_sc_hd__or2_1
XFILLER_0_88_184 VGND VGND VPWR VPWR sky130_fd_sc_hd__fill_1
XFILLER_0_88_162 VGND VGND VPWR VPWR sky130_fd_sc_hd__fill_1
XFILLER_0_88_151 VGND VGND VPWR VPWR sky130_fd_sc_hd__fill_2
XTAP_TAPCELL_ROW_49_485 VGND VPWR sky130_fd_sc_hd__tapvpwrvgnd_1
X_5814_ _0517_ _0014_ VGND VGND VPWR VPWR alu.ALUResult\[20\] sky130_fd_sc_hd__dlxtn_1
X_5745_ clknet_leaf_6_clk _0029_ VGND VGND VPWR VPWR clk_div.counter\[0\] sky130_fd_sc_hd__dfxtp_1
X_2957_ _0549_ _0621_ _0563_ _0585_ VGND VGND VPWR VPWR _0622_ sky130_fd_sc_hd__a2bb2o_1
X_4627_ _1654_ _2065_ _2245_ VGND VGND VPWR VPWR _2246_ sky130_fd_sc_hd__a21oi_1
XFILLER_0_44_221 VGND VGND VPWR VPWR sky130_fd_sc_hd__fill_1
X_2888_ _0552_ VGND VGND VPWR VPWR _0553_ sky130_fd_sc_hd__clkbuf_4
XTAP_TAPCELL_ROW_32_385 VGND VPWR sky130_fd_sc_hd__tapvpwrvgnd_1
X_5676_ reg_file.memory\[2\]\[9\] VGND VGND VPWR VPWR _2841_ sky130_fd_sc_hd__clkbuf_1
X_4489_ _1743_ _2118_ _2119_ VGND VGND VPWR VPWR _2120_ sky130_fd_sc_hd__or3b_1
X_6228_ clknet_leaf_4_clk _0463_ VGND VGND VPWR VPWR reg_file.memory\[2\]\[2\] sky130_fd_sc_hd__dfxtp_1
X_3509_ _0668_ _1169_ _1172_ _1173_ VGND VGND VPWR VPWR _1174_ sky130_fd_sc_hd__a31o_1
X_4558_ _2182_ _2168_ _1314_ VGND VGND VPWR VPWR _2183_ sky130_fd_sc_hd__o21a_1
XFILLER_0_12_195 VGND VGND VPWR VPWR sky130_fd_sc_hd__fill_1
X_6159_ clknet_leaf_10_clk _0394_ VGND VGND VPWR VPWR reg_file.memory\[1\]\[29\] sky130_fd_sc_hd__dfxtp_1
XFILLER_0_35_210 VPWR VGND VPWR VGND sky130_ef_sc_hd__decap_12
XTAP_TAPCELL_ROW_23_330 VGND VPWR sky130_fd_sc_hd__tapvpwrvgnd_1
Xoutput5 net5 VGND VGND VPWR VPWR an[2] sky130_fd_sc_hd__buf_1
XTAP_TAPCELL_ROW_46_466 VGND VPWR sky130_fd_sc_hd__tapvpwrvgnd_1
X_5461_ _2728_ VGND VGND VPWR VPWR _0367_ sky130_fd_sc_hd__clkbuf_1
X_5530_ _2764_ VGND VGND VPWR VPWR _0400_ sky130_fd_sc_hd__clkbuf_1
X_3860_ seven_seg_conv.temp\[12\] alu.ALUResult\[12\] _1347_ VGND VGND VPWR VPWR _1516_
+ sky130_fd_sc_hd__mux2_1
X_3791_ _1436_ _1446_ VGND VGND VPWR VPWR _1447_ sky130_fd_sc_hd__nand2_1
X_4274_ _1719_ _1821_ VGND VGND VPWR VPWR _1917_ sky130_fd_sc_hd__nand2_1
X_4412_ _1659_ _1756_ _1763_ VGND VGND VPWR VPWR _2048_ sky130_fd_sc_hd__o21a_1
X_4343_ _1770_ _1777_ VGND VGND VPWR VPWR _1983_ sky130_fd_sc_hd__and2b_1
X_5392_ _2411_ reg_file.memory\[15\]\[1\] _2691_ VGND VGND VPWR VPWR _2693_ sky130_fd_sc_hd__mux2_1
XFILLER_0_1_310 VGND VGND VPWR VPWR sky130_fd_sc_hd__decap_4
X_3087_ _0751_ reg_file.memory\[10\]\[25\] _0649_ VGND VGND VPWR VPWR _0752_ sky130_fd_sc_hd__mux2_1
X_3156_ reg_file.memory\[25\]\[21\] _0820_ _0670_ VGND VGND VPWR VPWR _0821_ sky130_fd_sc_hd__mux2_2
XTAP_TAPCELL_ROW_37_411 VGND VPWR sky130_fd_sc_hd__tapvpwrvgnd_1
XFILLER_0_27_70 VGND VGND VPWR VPWR sky130_fd_sc_hd__fill_2
X_6013_ clknet_leaf_25_clk _0248_ VGND VGND VPWR VPWR reg_file.memory\[8\]\[11\] sky130_fd_sc_hd__dfxtp_1
Xclkbuf_leaf_19_clk clknet_1_0__leaf_clk VGND VGND VPWR VPWR clknet_leaf_19_clk sky130_fd_sc_hd__clkbuf_8
X_3225_ _0573_ _0887_ _0889_ _0606_ VGND VGND VPWR VPWR _0890_ sky130_fd_sc_hd__o211a_1
XFILLER_0_49_346 VGND VGND VPWR VPWR sky130_fd_sc_hd__fill_2
XFILLER_0_49_335 VGND VGND VPWR VPWR sky130_fd_sc_hd__fill_1
XFILLER_0_49_324 VGND VGND VPWR VPWR sky130_fd_sc_hd__fill_2
X_5728_ _2296_ net9 _2291_ _2867_ VGND VGND VPWR VPWR _0495_ sky130_fd_sc_hd__o22a_1
X_5659_ _2832_ VGND VGND VPWR VPWR _0461_ sky130_fd_sc_hd__clkbuf_1
X_3989_ _0016_ _0017_ _1638_ _1640_ VGND VGND VPWR VPWR _0001_ sky130_fd_sc_hd__o22a_1
XTAP_TAPCELL_ROW_20_311 VGND VPWR sky130_fd_sc_hd__tapvpwrvgnd_1
XFILLER_0_67_110 VGND VGND VPWR VPWR sky130_fd_sc_hd__fill_2
XFILLER_0_82_179 VGND VGND VPWR VPWR sky130_fd_sc_hd__fill_1
XTAP_TAPCELL_ROW_43_447 VGND VPWR sky130_fd_sc_hd__tapvpwrvgnd_1
XFILLER_0_23_257 VGND VGND VPWR VPWR sky130_fd_sc_hd__fill_2
X_3010_ reg_file.memory\[7\]\[29\] _0674_ _0601_ reg_file.memory\[2\]\[29\] _0581_
+ VGND VGND VPWR VPWR _0675_ sky130_fd_sc_hd__o221a_1
X_4961_ _2461_ reg_file.memory\[4\]\[25\] _2451_ VGND VGND VPWR VPWR _2462_ sky130_fd_sc_hd__mux2_1
XFILLER_0_58_187 VGND VGND VPWR VPWR sky130_fd_sc_hd__fill_1
X_4892_ alu.ALUResult\[3\] VGND VGND VPWR VPWR _2415_ sky130_fd_sc_hd__buf_1
X_3843_ _1362_ VGND VGND VPWR VPWR _1499_ sky130_fd_sc_hd__inv_2
X_3912_ _1356_ _1567_ VGND VGND VPWR VPWR _1568_ sky130_fd_sc_hd__xnor2_1
X_5513_ _2754_ VGND VGND VPWR VPWR _0393_ sky130_fd_sc_hd__clkbuf_1
Xclkbuf_leaf_8_clk clknet_1_1__leaf_clk VGND VGND VPWR VPWR clknet_leaf_8_clk sky130_fd_sc_hd__clkbuf_8
X_5444_ _2463_ reg_file.memory\[15\]\[26\] _2713_ VGND VGND VPWR VPWR _2720_ sky130_fd_sc_hd__mux2_1
X_3774_ _1427_ _1428_ _1429_ VGND VGND VPWR VPWR _1430_ sky130_fd_sc_hd__nand3_1
X_4326_ _1708_ _1966_ VGND VGND VPWR VPWR _1967_ sky130_fd_sc_hd__nor2_1
XFILLER_0_59_3 VGND VGND VPWR VPWR sky130_fd_sc_hd__fill_2
X_4257_ _1177_ _1153_ _1176_ VGND VGND VPWR VPWR _1901_ sky130_fd_sc_hd__and3_1
X_5375_ reg_file.memory\[10\]\[26\] alu.ALUResult\[26\] _2676_ VGND VGND VPWR VPWR
+ _2683_ sky130_fd_sc_hd__mux2_1
X_4188_ _1119_ _1697_ _1679_ VGND VGND VPWR VPWR _1833_ sky130_fd_sc_hd__a21o_1
XTAP_TAPCELL_ROW_65_583 VGND VPWR sky130_fd_sc_hd__tapvpwrvgnd_1
X_3139_ _0801_ _0803_ _0665_ VGND VGND VPWR VPWR _0804_ sky130_fd_sc_hd__mux2_1
X_3208_ _0599_ _0872_ VGND VGND VPWR VPWR _0873_ sky130_fd_sc_hd__or2_1
XFILLER_0_64_168 VGND VGND VPWR VPWR sky130_fd_sc_hd__decap_4
XTAP_TAPCELL_ROW_40_428 VGND VPWR sky130_fd_sc_hd__tapvpwrvgnd_1
XFILLER_0_60_352 VGND VGND VPWR VPWR sky130_fd_sc_hd__fill_1
XFILLER_0_0_3 VPWR VGND VPWR VGND sky130_ef_sc_hd__decap_12
XFILLER_0_55_124 VGND VGND VPWR VPWR sky130_fd_sc_hd__decap_4
XFILLER_0_70_138 VGND VGND VPWR VPWR sky130_fd_sc_hd__fill_2
X_3490_ _1154_ _1152_ VGND VGND VPWR VPWR _1155_ sky130_fd_sc_hd__and2_1
XFILLER_0_55_157 VGND VGND VPWR VPWR sky130_fd_sc_hd__decap_3
X_4111_ _0981_ _1697_ VGND VGND VPWR VPWR _1757_ sky130_fd_sc_hd__nand2_1
X_5160_ _2547_ VGND VGND VPWR VPWR _2570_ sky130_fd_sc_hd__buf_4
X_5091_ _2533_ VGND VGND VPWR VPWR _0192_ sky130_fd_sc_hd__clkbuf_1
X_4042_ _1678_ _1685_ _1687_ VGND VGND VPWR VPWR _1688_ sky130_fd_sc_hd__mux2_1
X_5993_ clknet_leaf_10_clk _0228_ VGND VGND VPWR VPWR reg_file.memory\[7\]\[23\] sky130_fd_sc_hd__dfxtp_1
XTAP_TAPCELL_ROW_79_664 VGND VPWR sky130_fd_sc_hd__tapvpwrvgnd_1
XTAP_TAPCELL_ROW_62_564 VGND VPWR sky130_fd_sc_hd__tapvpwrvgnd_1
X_4875_ alu.ALUResult\[0\] VGND VGND VPWR VPWR _2401_ sky130_fd_sc_hd__buf_1
XFILLER_0_46_102 VGND VGND VPWR VPWR sky130_fd_sc_hd__decap_3
X_4944_ alu.ALUResult\[20\] VGND VGND VPWR VPWR _2450_ sky130_fd_sc_hd__buf_1
X_3826_ _1364_ _1481_ VGND VGND VPWR VPWR _1482_ sky130_fd_sc_hd__xnor2_1
X_3688_ _1344_ seven_seg_conv.digit_counter\[2\] seven_seg_conv.digit_counter\[0\]
+ seven_seg_conv.digit_counter\[1\] VGND VGND VPWR VPWR _1345_ sky130_fd_sc_hd__nor4_4
X_5427_ _2446_ reg_file.memory\[15\]\[18\] _2702_ VGND VGND VPWR VPWR _2711_ sky130_fd_sc_hd__mux2_1
X_3757_ _1371_ _1409_ _1410_ _1412_ VGND VGND VPWR VPWR _1413_ sky130_fd_sc_hd__a22o_1
X_4309_ _1658_ _1948_ _1949_ _1950_ VGND VGND VPWR VPWR _1951_ sky130_fd_sc_hd__a2bb2o_1
XPHY_EDGE_ROW_58_Left_149 VGND VGND VPWR VPWR sky130_fd_sc_hd__decap_3
X_5358_ reg_file.memory\[10\]\[18\] alu.ALUResult\[18\] _2665_ VGND VGND VPWR VPWR
+ _2674_ sky130_fd_sc_hd__mux2_1
X_5289_ reg_file.memory\[0\]\[17\] VGND VGND VPWR VPWR _2638_ sky130_fd_sc_hd__clkbuf_1
XFILLER_0_69_249 VPWR VGND VPWR VGND sky130_ef_sc_hd__decap_12
XPHY_EDGE_ROW_67_Left_158 VGND VGND VPWR VPWR sky130_fd_sc_hd__decap_3
XFILLER_0_25_319 VGND VGND VPWR VPWR sky130_fd_sc_hd__fill_1
XPHY_EDGE_ROW_76_Left_167 VGND VGND VPWR VPWR sky130_fd_sc_hd__decap_3
XTAP_TAPCELL_ROW_76_645 VGND VPWR sky130_fd_sc_hd__tapvpwrvgnd_1
XPHY_EDGE_ROW_85_Left_176 VGND VGND VPWR VPWR sky130_fd_sc_hd__decap_3
X_4660_ _1963_ _1717_ _1722_ _2275_ VGND VGND VPWR VPWR _2276_ sky130_fd_sc_hd__a31o_1
XTAP_TAPCELL_ROW_16_288 VGND VPWR sky130_fd_sc_hd__tapvpwrvgnd_1
X_2990_ _0654_ VGND VGND VPWR VPWR _0655_ sky130_fd_sc_hd__clkbuf_4
X_6261_ clk_div.slow_clk _0496_ VGND VGND VPWR VPWR net8 sky130_fd_sc_hd__dfxtp_1
X_3473_ reg_file.memory\[4\]\[1\] reg_file.memory\[5\]\[1\] _0588_ VGND VGND VPWR
+ VPWR _1138_ sky130_fd_sc_hd__mux2_1
X_4591_ _1816_ _2171_ VGND VGND VPWR VPWR _2213_ sky130_fd_sc_hd__nand2_1
X_3542_ _0959_ _0966_ _1206_ VGND VGND VPWR VPWR _1207_ sky130_fd_sc_hd__a21oi_1
X_3611_ _1208_ VGND VGND VPWR VPWR _1276_ sky130_fd_sc_hd__inv_2
X_6192_ clknet_leaf_14_clk _0427_ VGND VGND VPWR VPWR reg_file.memory\[21\]\[30\]
+ sky130_fd_sc_hd__dfxtp_1
X_5212_ reg_file.memory\[8\]\[11\] alu.ALUResult\[11\] _2597_ VGND VGND VPWR VPWR
+ _2599_ sky130_fd_sc_hd__mux2_1
X_5143_ _2561_ VGND VGND VPWR VPWR _0216_ sky130_fd_sc_hd__clkbuf_1
X_5074_ _2432_ reg_file.memory\[6\]\[11\] _2523_ VGND VGND VPWR VPWR _2525_ sky130_fd_sc_hd__mux2_1
X_4025_ _1670_ VGND VGND VPWR VPWR _1671_ sky130_fd_sc_hd__buf_2
X_5976_ clknet_leaf_0_clk _0211_ VGND VGND VPWR VPWR reg_file.memory\[7\]\[6\] sky130_fd_sc_hd__dfxtp_1
XFILLER_0_74_230 VGND VGND VPWR VPWR sky130_fd_sc_hd__fill_2
X_4858_ reg_file.memory\[9\]\[24\] VGND VGND VPWR VPWR _2393_ sky130_fd_sc_hd__clkbuf_1
X_3809_ _1366_ _1464_ VGND VGND VPWR VPWR _1465_ sky130_fd_sc_hd__xnor2_2
X_4789_ seven_seg_conv.temp\[19\] _1461_ _1635_ VGND VGND VPWR VPWR _2358_ sky130_fd_sc_hd__mux2_1
XFILLER_0_19_135 VGND VGND VPWR VPWR sky130_fd_sc_hd__fill_2
X_4927_ _2438_ reg_file.memory\[4\]\[14\] _2430_ VGND VGND VPWR VPWR _2439_ sky130_fd_sc_hd__mux2_1
XTAP_TAPCELL_ROW_7_234 VGND VPWR sky130_fd_sc_hd__tapvpwrvgnd_1
XTAP_TAPCELL_ROW_73_626 VGND VPWR sky130_fd_sc_hd__tapvpwrvgnd_1
XTAP_TAPCELL_ROW_13_269 VGND VPWR sky130_fd_sc_hd__tapvpwrvgnd_1
XFILLER_0_21_311 VGND VGND VPWR VPWR sky130_fd_sc_hd__fill_2
XFILLER_0_0_238 VGND VGND VPWR VPWR sky130_fd_sc_hd__fill_2
X_5830_ clknet_leaf_27_clk _0080_ VGND VGND VPWR VPWR reg_file.memory\[9\]\[4\] sky130_fd_sc_hd__dfxtp_1
X_4712_ clk_div.counter\[5\] _2308_ VGND VGND VPWR VPWR _2313_ sky130_fd_sc_hd__nor2_1
X_5761_ clknet_leaf_6_clk _0045_ VGND VGND VPWR VPWR clk_div.counter\[16\] sky130_fd_sc_hd__dfxtp_1
XFILLER_0_71_244 VGND VGND VPWR VPWR sky130_fd_sc_hd__fill_1
XFILLER_0_71_200 VGND VGND VPWR VPWR sky130_fd_sc_hd__fill_1
X_4643_ _0698_ _0705_ VGND VGND VPWR VPWR _2260_ sky130_fd_sc_hd__and2b_1
X_2973_ _0637_ VGND VGND VPWR VPWR _0638_ sky130_fd_sc_hd__clkbuf_4
XFILLER_0_21_72 VGND VGND VPWR VPWR sky130_fd_sc_hd__fill_1
X_5692_ reg_file.memory\[2\]\[17\] VGND VGND VPWR VPWR _2849_ sky130_fd_sc_hd__clkbuf_1
X_3456_ reg_file.memory\[0\]\[2\] reg_file.memory\[1\]\[2\] _0589_ VGND VGND VPWR
+ VPWR _1121_ sky130_fd_sc_hd__mux2_1
X_4574_ _0798_ _0805_ VGND VGND VPWR VPWR _2197_ sky130_fd_sc_hd__and2b_1
X_3525_ _1038_ _1045_ VGND VGND VPWR VPWR _1190_ sky130_fd_sc_hd__or2_1
X_6244_ clknet_leaf_17_clk _0479_ VGND VGND VPWR VPWR reg_file.memory\[2\]\[18\] sky130_fd_sc_hd__dfxtp_1
X_4008_ _1091_ VGND VGND VPWR VPWR _1654_ sky130_fd_sc_hd__inv_2
X_5057_ _2415_ reg_file.memory\[6\]\[3\] _2512_ VGND VGND VPWR VPWR _2516_ sky130_fd_sc_hd__mux2_1
X_5126_ _2552_ VGND VGND VPWR VPWR _0208_ sky130_fd_sc_hd__clkbuf_1
X_6175_ clknet_leaf_22_clk _0410_ VGND VGND VPWR VPWR reg_file.memory\[21\]\[13\]
+ sky130_fd_sc_hd__dfxtp_1
X_3387_ _0571_ _1049_ _1051_ _0605_ VGND VGND VPWR VPWR _1052_ sky130_fd_sc_hd__o211a_1
XTAP_TAPCELL_ROW_4_215 VGND VPWR sky130_fd_sc_hd__tapvpwrvgnd_1
X_5959_ clknet_leaf_16_clk _0194_ VGND VGND VPWR VPWR reg_file.memory\[6\]\[21\] sky130_fd_sc_hd__dfxtp_1
XFILLER_0_1_71 VGND VGND VPWR VPWR sky130_fd_sc_hd__decap_4
XFILLER_0_62_222 VGND VGND VPWR VPWR sky130_fd_sc_hd__fill_2
XFILLER_0_5_308 VGND VGND VPWR VPWR sky130_fd_sc_hd__fill_2
XFILLER_0_5_319 VGND VGND VPWR VPWR sky130_fd_sc_hd__decap_3
X_4290_ _1733_ _1932_ VGND VGND VPWR VPWR _1933_ sky130_fd_sc_hd__nor2_1
XANTENNA_4 _2053_ VGND VGND VPWR VPWR sky130_fd_sc_hd__diode_2
XFILLER_0_6_27 VGND VGND VPWR VPWR sky130_fd_sc_hd__fill_1
X_3310_ reg_file.memory\[6\]\[11\] reg_file.memory\[7\]\[11\] _0637_ VGND VGND VPWR
+ VPWR _0975_ sky130_fd_sc_hd__mux2_1
XFILLER_0_83_45 VGND VGND VPWR VPWR sky130_fd_sc_hd__fill_1
XFILLER_0_83_23 VGND VGND VPWR VPWR sky130_fd_sc_hd__decap_6
X_3172_ reg_file.memory\[25\]\[20\] _0836_ _0670_ VGND VGND VPWR VPWR _0837_ sky130_fd_sc_hd__mux2_2
X_3241_ reg_file.memory\[0\]\[15\] reg_file.memory\[1\]\[15\] _0592_ VGND VGND VPWR
+ VPWR _0906_ sky130_fd_sc_hd__mux2_1
XTAP_TAPCELL_ROW_49_486 VGND VPWR sky130_fd_sc_hd__tapvpwrvgnd_1
X_5813_ _0515_ _0014_ VGND VGND VPWR VPWR alu.ALUResult\[19\] sky130_fd_sc_hd__dlxtn_1
XFILLER_0_29_263 VGND VGND VPWR VPWR sky130_fd_sc_hd__fill_1
XFILLER_0_89_3 VGND VGND VPWR VPWR sky130_fd_sc_hd__fill_2
X_5744_ net1 _0011_ _0028_ VGND VGND VPWR VPWR PC\[4\] sky130_fd_sc_hd__dfrtp_4
X_2956_ _0547_ _0555_ _0576_ VGND VGND VPWR VPWR _0621_ sky130_fd_sc_hd__o21ai_1
X_4626_ _2068_ _2135_ _2244_ _1952_ VGND VGND VPWR VPWR _2245_ sky130_fd_sc_hd__o31ai_1
X_2887_ _0551_ VGND VGND VPWR VPWR _0552_ sky130_fd_sc_hd__buf_2
X_5675_ _2840_ VGND VGND VPWR VPWR _0469_ sky130_fd_sc_hd__clkbuf_1
X_6158_ clknet_leaf_9_clk _0393_ VGND VGND VPWR VPWR reg_file.memory\[1\]\[28\] sky130_fd_sc_hd__dfxtp_1
X_4488_ _1889_ _2009_ _2002_ _1707_ VGND VGND VPWR VPWR _2119_ sky130_fd_sc_hd__o22a_1
X_6227_ clknet_leaf_4_clk _0462_ VGND VGND VPWR VPWR reg_file.memory\[2\]\[1\] sky130_fd_sc_hd__dfxtp_1
X_3508_ reg_file.memory\[25\]\[0\] _0668_ VGND VGND VPWR VPWR _1173_ sky130_fd_sc_hd__nor2_1
X_4557_ _0830_ _0837_ VGND VGND VPWR VPWR _2182_ sky130_fd_sc_hd__and2b_1
X_3439_ reg_file.memory\[15\]\[3\] _0609_ _0543_ _1103_ VGND VGND VPWR VPWR _1104_
+ sky130_fd_sc_hd__o211a_1
X_5109_ _2467_ reg_file.memory\[6\]\[28\] _2534_ VGND VGND VPWR VPWR _2543_ sky130_fd_sc_hd__mux2_1
XFILLER_0_79_163 VGND VGND VPWR VPWR sky130_fd_sc_hd__decap_4
X_6089_ clknet_leaf_10_clk _0324_ VGND VGND VPWR VPWR reg_file.memory\[10\]\[23\]
+ sky130_fd_sc_hd__dfxtp_1
XFILLER_0_35_233 VGND VGND VPWR VPWR sky130_fd_sc_hd__fill_1
XFILLER_0_35_222 VGND VGND VPWR VPWR sky130_fd_sc_hd__fill_2
XTAP_TAPCELL_ROW_23_331 VGND VPWR sky130_fd_sc_hd__tapvpwrvgnd_1
Xoutput6 net6 VGND VGND VPWR VPWR an[3] sky130_fd_sc_hd__buf_1
XFILLER_0_85_144 VPWR VGND VPWR VGND sky130_ef_sc_hd__decap_12
XFILLER_0_85_111 VGND VGND VPWR VPWR sky130_fd_sc_hd__fill_1
XTAP_TAPCELL_ROW_46_467 VGND VPWR sky130_fd_sc_hd__tapvpwrvgnd_1
X_4411_ _1658_ _1896_ VGND VGND VPWR VPWR _2047_ sky130_fd_sc_hd__nor2_1
XFILLER_0_78_23 VGND VGND VPWR VPWR sky130_fd_sc_hd__fill_1
X_5460_ reg_file.memory\[1\]\[2\] VGND VGND VPWR VPWR _2728_ sky130_fd_sc_hd__clkbuf_1
XFILLER_0_41_225 VGND VGND VPWR VPWR sky130_fd_sc_hd__fill_2
X_3790_ _1369_ _1445_ VGND VGND VPWR VPWR _1446_ sky130_fd_sc_hd__nand2_1
X_4273_ _1915_ VGND VGND VPWR VPWR _1916_ sky130_fd_sc_hd__inv_2
X_4342_ _1880_ VGND VGND VPWR VPWR _1982_ sky130_fd_sc_hd__inv_2
X_5391_ _2692_ VGND VGND VPWR VPWR _0333_ sky130_fd_sc_hd__clkbuf_1
X_6012_ clknet_leaf_25_clk _0247_ VGND VGND VPWR VPWR reg_file.memory\[8\]\[10\] sky130_fd_sc_hd__dfxtp_1
X_3224_ _0599_ _0888_ VGND VGND VPWR VPWR _0889_ sky130_fd_sc_hd__or2_1
.ends
